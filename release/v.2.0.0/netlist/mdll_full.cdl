* ===== pnr/runs/CMOS5L_2026-11-04_14-28-46/final/cdl/mdll.cdl
* CDL Netlist generated by OpenROAD

*.BUSDELIMITER [

.SUBCKT mdll clk_out clk_ref code[0] code[1] code[2] code[3]  code[4] code[5] code[6] code[7] locked resetb VPWR VGND
Xx1 net7 net8 net9 net10 net11 net12 net13 net14 rstb_gen  net6 clk_ref div inj_sel VPWR VGND clk_gen
Xx10 rstb_gen net2 clk_ref net18 net5 VPWR VGND sg13cmos5l_dfrbp_1
Xx11 clk_ref_n clk_ref VPWR VGND sg13cmos5l_inv_1
Xx12 rstb_ctl net3 clk_ref_n rstb_gen net5 VPWR VGND sg13cmos5l_dfrbp_1
Xx5_13 net16 VPWR VGND sg13cmos5l_tiehi
Xx2 div clk_ref_g tdc_sel tdc_start busy hit tdc_f\[0\] tdc_f\[1\]  tdc_f\[2\] tdc_f\[3\] tdc_f\[4\] tdc_f\[5\] tdc_f\[6\] tdc_f\[7\]  tdc_s\[0\] tdc_s\[1\] tdc_s\[2\] tdc_s\[3\] tdc_s\[4\] tdc_s\[5\]  tdc_s\[6\] tdc_s\[7\] tdc_valid VPWR VGND tdc
Xx3 net7 net8 net9 net10 net11 net12 net13 net14 clk_ref_g  comp div load rstb_ctl seed\[0\] seed\[1\] seed\[2\] seed\[3\]  seed\[4\] seed\[5\] seed\[6\] seed\[7\] VPWR VGND bbpd
Xx4 busy clk_ref net7 net8 net9 net10 net11 net12 net13 net14  hit inj_sel load net15 rstb_ctl seed\[0\] seed\[1\] seed\[2\]  seed\[3\] seed\[4\] seed\[5\] seed\[6\] seed\[7\] tdc_sel  tdc_start tdc_f\[0\] tdc_f\[1\] tdc_f\[2\] tdc_f\[3\] tdc_f\[4\]  tdc_f\[5\] tdc_f\[6\] tdc_f\[7\] tdc_s\[0\] tdc_s\[1\] tdc_s\[2\]  tdc_s\[3\] tdc_s\[4\] tdc_s\[5\] tdc_s\[6\] tdc_s\[7\] VPWR  VGND lock_ctrl
Xx5 clk_ref_x5 clk_ref net16 VPWR VGND sg13cmos5l_lgcp_1
Xhold15 net18 rstb_s1 VPWR VGND sg13cmos5l_dlygate4sd3_1
Xx7 clk_ref_g clk_ref_x5 VPWR VGND sg13cmos5l_buf_4
Xx8 net4 clk_ref_g net17 VPWR VGND sg13cmos5l_nor2b_1
Xx9 rstb_s1 net1 clk_ref net net5 VPWR VGND sg13cmos5l_dfrbp_1
Xinput1 net5 resetb VPWR VGND sg13cmos5l_buf_1
Xoutput2 clk_out net6 VPWR VGND sg13cmos5l_buf_1
Xoutput3 code[0] net7 VPWR VGND sg13cmos5l_buf_1
Xoutput4 code[1] net8 VPWR VGND sg13cmos5l_buf_1
Xoutput5 code[2] net9 VPWR VGND sg13cmos5l_buf_1
Xoutput6 code[3] net10 VPWR VGND sg13cmos5l_buf_1
Xoutput7 code[4] net11 VPWR VGND sg13cmos5l_buf_1
Xoutput8 code[5] net12 VPWR VGND sg13cmos5l_buf_1
Xoutput9 code[6] net13 VPWR VGND sg13cmos5l_buf_1
Xoutput10 code[7] net14 VPWR VGND sg13cmos5l_buf_1
Xoutput11 locked net15 VPWR VGND sg13cmos5l_buf_1
Xx9_12 net VPWR VGND sg13cmos5l_tiehi
Xx8_14 net17 VPWR VGND sg13cmos5l_tiehi
XANTENNA_1 net8 VPWR VGND sg13cmos5l_antennanp
XANTENNA_2 net10 VPWR VGND sg13cmos5l_antennanp
XANTENNA_3 net11 VPWR VGND sg13cmos5l_antennanp
XANTENNA_4 net12 VPWR VGND sg13cmos5l_antennanp
XANTENNA_5 net13 VPWR VGND sg13cmos5l_antennanp
XANTENNA_6 net14 VPWR VGND sg13cmos5l_antennanp
XANTENNA_7 net15 VPWR VGND sg13cmos5l_antennanp
XFILLER_0_446 VPWR VGND sg13cmos5l_decap_8
XFILLER_0_453 VPWR VGND sg13cmos5l_decap_8
XFILLER_0_460 VPWR VGND sg13cmos5l_decap_8
XFILLER_0_467 VPWR VGND sg13cmos5l_decap_8
XFILLER_0_474 VPWR VGND sg13cmos5l_decap_8
XFILLER_0_481 VPWR VGND sg13cmos5l_decap_8
XFILLER_0_488 VPWR VGND sg13cmos5l_decap_8
XFILLER_0_495 VPWR VGND sg13cmos5l_decap_8
XFILLER_0_502 VPWR VGND sg13cmos5l_decap_4
XFILLER_1_446 VPWR VGND sg13cmos5l_decap_8
XFILLER_1_453 VPWR VGND sg13cmos5l_decap_8
XFILLER_1_460 VPWR VGND sg13cmos5l_decap_8
XFILLER_1_467 VPWR VGND sg13cmos5l_decap_8
XFILLER_1_474 VPWR VGND sg13cmos5l_decap_8
XFILLER_1_481 VPWR VGND sg13cmos5l_decap_8
XFILLER_1_488 VPWR VGND sg13cmos5l_decap_8
XFILLER_1_495 VPWR VGND sg13cmos5l_decap_8
XFILLER_1_502 VPWR VGND sg13cmos5l_decap_8
XFILLER_1_509 VPWR VGND sg13cmos5l_decap_4
XFILLER_2_446 VPWR VGND sg13cmos5l_decap_8
XFILLER_2_453 VPWR VGND sg13cmos5l_decap_8
XFILLER_2_460 VPWR VGND sg13cmos5l_decap_8
XFILLER_2_467 VPWR VGND sg13cmos5l_decap_8
XFILLER_2_474 VPWR VGND sg13cmos5l_decap_8
XFILLER_2_481 VPWR VGND sg13cmos5l_decap_8
XFILLER_2_488 VPWR VGND sg13cmos5l_decap_8
XFILLER_2_495 VPWR VGND sg13cmos5l_decap_8
XFILLER_2_502 VPWR VGND sg13cmos5l_decap_8
XFILLER_2_509 VPWR VGND sg13cmos5l_decap_4
XFILLER_3_446 VPWR VGND sg13cmos5l_decap_8
XFILLER_3_453 VPWR VGND sg13cmos5l_decap_8
XFILLER_3_460 VPWR VGND sg13cmos5l_decap_8
XFILLER_3_467 VPWR VGND sg13cmos5l_decap_8
XFILLER_3_474 VPWR VGND sg13cmos5l_decap_8
XFILLER_3_481 VPWR VGND sg13cmos5l_decap_8
XFILLER_3_488 VPWR VGND sg13cmos5l_decap_8
XFILLER_3_495 VPWR VGND sg13cmos5l_decap_8
XFILLER_3_502 VPWR VGND sg13cmos5l_decap_8
XFILLER_3_509 VPWR VGND sg13cmos5l_decap_4
XFILLER_4_446 VPWR VGND sg13cmos5l_decap_8
XFILLER_4_453 VPWR VGND sg13cmos5l_decap_8
XFILLER_4_460 VPWR VGND sg13cmos5l_decap_8
XFILLER_4_467 VPWR VGND sg13cmos5l_decap_8
XFILLER_4_474 VPWR VGND sg13cmos5l_decap_8
XFILLER_4_481 VPWR VGND sg13cmos5l_decap_8
XFILLER_4_488 VPWR VGND sg13cmos5l_decap_8
XFILLER_4_495 VPWR VGND sg13cmos5l_decap_8
XFILLER_4_502 VPWR VGND sg13cmos5l_decap_8
XFILLER_4_509 VPWR VGND sg13cmos5l_decap_4
XFILLER_5_446 VPWR VGND sg13cmos5l_decap_8
XFILLER_5_453 VPWR VGND sg13cmos5l_decap_8
XFILLER_5_460 VPWR VGND sg13cmos5l_decap_8
XFILLER_5_467 VPWR VGND sg13cmos5l_decap_8
XFILLER_5_474 VPWR VGND sg13cmos5l_decap_8
XFILLER_5_481 VPWR VGND sg13cmos5l_decap_8
XFILLER_5_488 VPWR VGND sg13cmos5l_decap_8
XFILLER_5_495 VPWR VGND sg13cmos5l_decap_8
XFILLER_5_502 VPWR VGND sg13cmos5l_decap_8
XFILLER_5_509 VPWR VGND sg13cmos5l_decap_4
XFILLER_6_446 VPWR VGND sg13cmos5l_decap_8
XFILLER_6_453 VPWR VGND sg13cmos5l_decap_8
XFILLER_6_460 VPWR VGND sg13cmos5l_decap_8
XFILLER_6_467 VPWR VGND sg13cmos5l_decap_8
XFILLER_6_474 VPWR VGND sg13cmos5l_decap_8
XFILLER_6_481 VPWR VGND sg13cmos5l_decap_8
XFILLER_6_488 VPWR VGND sg13cmos5l_decap_8
XFILLER_6_495 VPWR VGND sg13cmos5l_decap_8
XFILLER_6_502 VPWR VGND sg13cmos5l_decap_8
XFILLER_6_509 VPWR VGND sg13cmos5l_decap_4
XFILLER_7_446 VPWR VGND sg13cmos5l_decap_8
XFILLER_7_453 VPWR VGND sg13cmos5l_decap_8
XFILLER_7_460 VPWR VGND sg13cmos5l_decap_8
XFILLER_7_467 VPWR VGND sg13cmos5l_decap_8
XFILLER_7_474 VPWR VGND sg13cmos5l_decap_8
XFILLER_7_481 VPWR VGND sg13cmos5l_decap_8
XFILLER_7_488 VPWR VGND sg13cmos5l_decap_8
XFILLER_7_495 VPWR VGND sg13cmos5l_decap_8
XFILLER_7_502 VPWR VGND sg13cmos5l_decap_8
XFILLER_7_509 VPWR VGND sg13cmos5l_decap_4
XFILLER_8_446 VPWR VGND sg13cmos5l_decap_8
XFILLER_8_453 VPWR VGND sg13cmos5l_decap_8
XFILLER_8_460 VPWR VGND sg13cmos5l_decap_8
XFILLER_8_467 VPWR VGND sg13cmos5l_decap_8
XFILLER_8_474 VPWR VGND sg13cmos5l_decap_8
XFILLER_8_481 VPWR VGND sg13cmos5l_decap_8
XFILLER_8_488 VPWR VGND sg13cmos5l_decap_8
XFILLER_8_495 VPWR VGND sg13cmos5l_decap_8
XFILLER_8_502 VPWR VGND sg13cmos5l_decap_8
XFILLER_8_509 VPWR VGND sg13cmos5l_decap_4
XFILLER_9_446 VPWR VGND sg13cmos5l_decap_8
XFILLER_9_453 VPWR VGND sg13cmos5l_decap_8
XFILLER_9_460 VPWR VGND sg13cmos5l_decap_8
XFILLER_9_467 VPWR VGND sg13cmos5l_decap_8
XFILLER_9_474 VPWR VGND sg13cmos5l_decap_8
XFILLER_9_481 VPWR VGND sg13cmos5l_decap_8
XFILLER_9_488 VPWR VGND sg13cmos5l_decap_8
XFILLER_9_495 VPWR VGND sg13cmos5l_decap_8
XFILLER_9_502 VPWR VGND sg13cmos5l_decap_8
XFILLER_10_446 VPWR VGND sg13cmos5l_decap_8
XFILLER_10_453 VPWR VGND sg13cmos5l_decap_8
XFILLER_10_460 VPWR VGND sg13cmos5l_decap_8
XFILLER_10_467 VPWR VGND sg13cmos5l_decap_8
XFILLER_10_474 VPWR VGND sg13cmos5l_decap_8
XFILLER_10_481 VPWR VGND sg13cmos5l_decap_8
XFILLER_10_488 VPWR VGND sg13cmos5l_decap_8
XFILLER_10_495 VPWR VGND sg13cmos5l_decap_8
XFILLER_10_502 VPWR VGND sg13cmos5l_decap_8
XFILLER_10_509 VPWR VGND sg13cmos5l_decap_4
XFILLER_11_446 VPWR VGND sg13cmos5l_decap_8
XFILLER_11_453 VPWR VGND sg13cmos5l_decap_8
XFILLER_11_460 VPWR VGND sg13cmos5l_decap_8
XFILLER_11_467 VPWR VGND sg13cmos5l_decap_8
XFILLER_11_474 VPWR VGND sg13cmos5l_decap_8
XFILLER_11_481 VPWR VGND sg13cmos5l_decap_8
XFILLER_11_488 VPWR VGND sg13cmos5l_decap_8
XFILLER_11_495 VPWR VGND sg13cmos5l_decap_8
XFILLER_11_502 VPWR VGND sg13cmos5l_decap_8
XFILLER_11_509 VPWR VGND sg13cmos5l_decap_4
XFILLER_12_446 VPWR VGND sg13cmos5l_decap_8
XFILLER_12_453 VPWR VGND sg13cmos5l_decap_8
XFILLER_12_460 VPWR VGND sg13cmos5l_decap_8
XFILLER_12_467 VPWR VGND sg13cmos5l_decap_8
XFILLER_12_474 VPWR VGND sg13cmos5l_decap_8
XFILLER_12_481 VPWR VGND sg13cmos5l_decap_8
XFILLER_12_488 VPWR VGND sg13cmos5l_decap_8
XFILLER_12_495 VPWR VGND sg13cmos5l_decap_8
XFILLER_12_502 VPWR VGND sg13cmos5l_decap_8
XFILLER_12_509 VPWR VGND sg13cmos5l_decap_4
XFILLER_13_446 VPWR VGND sg13cmos5l_decap_8
XFILLER_13_453 VPWR VGND sg13cmos5l_decap_8
XFILLER_13_460 VPWR VGND sg13cmos5l_decap_8
XFILLER_13_467 VPWR VGND sg13cmos5l_decap_8
XFILLER_13_474 VPWR VGND sg13cmos5l_decap_8
XFILLER_13_481 VPWR VGND sg13cmos5l_decap_8
XFILLER_13_488 VPWR VGND sg13cmos5l_decap_8
XFILLER_13_495 VPWR VGND sg13cmos5l_decap_8
XFILLER_13_502 VPWR VGND sg13cmos5l_decap_8
XFILLER_13_509 VPWR VGND sg13cmos5l_decap_4
XFILLER_14_446 VPWR VGND sg13cmos5l_decap_8
XFILLER_14_453 VPWR VGND sg13cmos5l_decap_8
XFILLER_14_460 VPWR VGND sg13cmos5l_decap_8
XFILLER_14_467 VPWR VGND sg13cmos5l_decap_8
XFILLER_14_474 VPWR VGND sg13cmos5l_decap_8
XFILLER_14_481 VPWR VGND sg13cmos5l_decap_8
XFILLER_14_488 VPWR VGND sg13cmos5l_decap_8
XFILLER_14_495 VPWR VGND sg13cmos5l_decap_8
XFILLER_14_502 VPWR VGND sg13cmos5l_decap_8
XFILLER_14_509 VPWR VGND sg13cmos5l_decap_4
XFILLER_15_446 VPWR VGND sg13cmos5l_decap_8
XFILLER_15_453 VPWR VGND sg13cmos5l_decap_8
XFILLER_15_460 VPWR VGND sg13cmos5l_decap_8
XFILLER_15_467 VPWR VGND sg13cmos5l_decap_8
XFILLER_15_474 VPWR VGND sg13cmos5l_decap_8
XFILLER_15_481 VPWR VGND sg13cmos5l_decap_8
XFILLER_15_488 VPWR VGND sg13cmos5l_decap_8
XFILLER_15_495 VPWR VGND sg13cmos5l_decap_8
XFILLER_15_502 VPWR VGND sg13cmos5l_decap_8
XFILLER_15_509 VPWR VGND sg13cmos5l_decap_4
XFILLER_16_446 VPWR VGND sg13cmos5l_decap_8
XFILLER_16_453 VPWR VGND sg13cmos5l_decap_8
XFILLER_16_460 VPWR VGND sg13cmos5l_decap_8
XFILLER_16_467 VPWR VGND sg13cmos5l_decap_8
XFILLER_16_474 VPWR VGND sg13cmos5l_decap_8
XFILLER_16_481 VPWR VGND sg13cmos5l_decap_8
XFILLER_16_488 VPWR VGND sg13cmos5l_decap_8
XFILLER_16_495 VPWR VGND sg13cmos5l_decap_8
XFILLER_16_502 VPWR VGND sg13cmos5l_decap_8
XFILLER_16_509 VPWR VGND sg13cmos5l_decap_4
XFILLER_17_446 VPWR VGND sg13cmos5l_decap_8
XFILLER_17_453 VPWR VGND sg13cmos5l_decap_8
XFILLER_17_460 VPWR VGND sg13cmos5l_decap_8
XFILLER_17_467 VPWR VGND sg13cmos5l_decap_8
XFILLER_17_474 VPWR VGND sg13cmos5l_decap_8
XFILLER_17_481 VPWR VGND sg13cmos5l_decap_8
XFILLER_17_488 VPWR VGND sg13cmos5l_decap_8
XFILLER_17_495 VPWR VGND sg13cmos5l_decap_8
XFILLER_17_502 VPWR VGND sg13cmos5l_decap_8
XFILLER_17_509 VPWR VGND sg13cmos5l_decap_4
XFILLER_18_446 VPWR VGND sg13cmos5l_decap_8
XFILLER_18_453 VPWR VGND sg13cmos5l_decap_8
XFILLER_18_460 VPWR VGND sg13cmos5l_decap_8
XFILLER_18_467 VPWR VGND sg13cmos5l_decap_8
XFILLER_18_474 VPWR VGND sg13cmos5l_decap_8
XFILLER_18_481 VPWR VGND sg13cmos5l_decap_8
XFILLER_18_488 VPWR VGND sg13cmos5l_decap_8
XFILLER_18_495 VPWR VGND sg13cmos5l_decap_8
XFILLER_18_502 VPWR VGND sg13cmos5l_decap_4
XFILLER_19_446 VPWR VGND sg13cmos5l_decap_8
XFILLER_19_453 VPWR VGND sg13cmos5l_decap_8
XFILLER_19_460 VPWR VGND sg13cmos5l_decap_8
XFILLER_19_467 VPWR VGND sg13cmos5l_decap_8
XFILLER_19_474 VPWR VGND sg13cmos5l_decap_8
XFILLER_19_481 VPWR VGND sg13cmos5l_decap_8
XFILLER_19_488 VPWR VGND sg13cmos5l_decap_8
XFILLER_19_495 VPWR VGND sg13cmos5l_decap_8
XFILLER_19_502 VPWR VGND sg13cmos5l_decap_8
XFILLER_19_509 VPWR VGND sg13cmos5l_decap_4
XFILLER_20_446 VPWR VGND sg13cmos5l_decap_8
XFILLER_20_453 VPWR VGND sg13cmos5l_decap_8
XFILLER_20_460 VPWR VGND sg13cmos5l_decap_8
XFILLER_20_467 VPWR VGND sg13cmos5l_decap_8
XFILLER_20_474 VPWR VGND sg13cmos5l_decap_8
XFILLER_20_481 VPWR VGND sg13cmos5l_decap_8
XFILLER_20_488 VPWR VGND sg13cmos5l_decap_8
XFILLER_20_495 VPWR VGND sg13cmos5l_decap_8
XFILLER_20_502 VPWR VGND sg13cmos5l_decap_8
XFILLER_20_509 VPWR VGND sg13cmos5l_decap_4
XFILLER_21_446 VPWR VGND sg13cmos5l_decap_8
XFILLER_21_453 VPWR VGND sg13cmos5l_decap_8
XFILLER_21_460 VPWR VGND sg13cmos5l_decap_8
XFILLER_21_467 VPWR VGND sg13cmos5l_decap_8
XFILLER_21_474 VPWR VGND sg13cmos5l_decap_8
XFILLER_21_481 VPWR VGND sg13cmos5l_decap_8
XFILLER_21_488 VPWR VGND sg13cmos5l_decap_8
XFILLER_21_495 VPWR VGND sg13cmos5l_decap_8
XFILLER_21_502 VPWR VGND sg13cmos5l_decap_8
XFILLER_21_509 VPWR VGND sg13cmos5l_decap_4
XFILLER_22_446 VPWR VGND sg13cmos5l_decap_8
XFILLER_22_453 VPWR VGND sg13cmos5l_decap_8
XFILLER_22_460 VPWR VGND sg13cmos5l_decap_8
XFILLER_22_467 VPWR VGND sg13cmos5l_decap_8
XFILLER_22_474 VPWR VGND sg13cmos5l_decap_8
XFILLER_22_481 VPWR VGND sg13cmos5l_decap_8
XFILLER_22_488 VPWR VGND sg13cmos5l_decap_8
XFILLER_22_495 VPWR VGND sg13cmos5l_decap_8
XFILLER_22_502 VPWR VGND sg13cmos5l_decap_8
XFILLER_22_509 VPWR VGND sg13cmos5l_decap_4
XFILLER_23_446 VPWR VGND sg13cmos5l_decap_8
XFILLER_23_453 VPWR VGND sg13cmos5l_decap_8
XFILLER_23_460 VPWR VGND sg13cmos5l_decap_8
XFILLER_23_467 VPWR VGND sg13cmos5l_decap_8
XFILLER_23_474 VPWR VGND sg13cmos5l_decap_8
XFILLER_23_481 VPWR VGND sg13cmos5l_decap_8
XFILLER_23_488 VPWR VGND sg13cmos5l_decap_8
XFILLER_23_495 VPWR VGND sg13cmos5l_decap_8
XFILLER_23_502 VPWR VGND sg13cmos5l_decap_8
XFILLER_23_509 VPWR VGND sg13cmos5l_decap_4
XFILLER_24_446 VPWR VGND sg13cmos5l_decap_8
XFILLER_24_453 VPWR VGND sg13cmos5l_decap_8
XFILLER_24_460 VPWR VGND sg13cmos5l_decap_8
XFILLER_24_467 VPWR VGND sg13cmos5l_decap_8
XFILLER_24_474 VPWR VGND sg13cmos5l_decap_8
XFILLER_24_481 VPWR VGND sg13cmos5l_decap_8
XFILLER_24_488 VPWR VGND sg13cmos5l_decap_8
XFILLER_24_495 VPWR VGND sg13cmos5l_decap_8
XFILLER_24_502 VPWR VGND sg13cmos5l_decap_8
XFILLER_24_509 VPWR VGND sg13cmos5l_decap_4
XFILLER_25_446 VPWR VGND sg13cmos5l_decap_8
XFILLER_25_453 VPWR VGND sg13cmos5l_decap_8
XFILLER_25_460 VPWR VGND sg13cmos5l_decap_8
XFILLER_25_467 VPWR VGND sg13cmos5l_decap_8
XFILLER_25_474 VPWR VGND sg13cmos5l_decap_8
XFILLER_25_481 VPWR VGND sg13cmos5l_decap_8
XFILLER_25_488 VPWR VGND sg13cmos5l_decap_8
XFILLER_25_495 VPWR VGND sg13cmos5l_decap_8
XFILLER_25_502 VPWR VGND sg13cmos5l_decap_8
XFILLER_25_509 VPWR VGND sg13cmos5l_decap_4
XFILLER_26_446 VPWR VGND sg13cmos5l_decap_8
XFILLER_26_453 VPWR VGND sg13cmos5l_decap_8
XFILLER_26_460 VPWR VGND sg13cmos5l_decap_8
XFILLER_26_467 VPWR VGND sg13cmos5l_decap_8
XFILLER_26_474 VPWR VGND sg13cmos5l_decap_8
XFILLER_26_481 VPWR VGND sg13cmos5l_decap_8
XFILLER_26_488 VPWR VGND sg13cmos5l_decap_8
XFILLER_26_495 VPWR VGND sg13cmos5l_decap_8
XFILLER_26_502 VPWR VGND sg13cmos5l_decap_8
XFILLER_27_446 VPWR VGND sg13cmos5l_decap_8
XFILLER_27_453 VPWR VGND sg13cmos5l_decap_8
XFILLER_27_460 VPWR VGND sg13cmos5l_decap_8
XFILLER_27_467 VPWR VGND sg13cmos5l_decap_8
XFILLER_27_474 VPWR VGND sg13cmos5l_decap_8
XFILLER_27_481 VPWR VGND sg13cmos5l_decap_8
XFILLER_27_488 VPWR VGND sg13cmos5l_decap_8
XFILLER_27_495 VPWR VGND sg13cmos5l_decap_8
XFILLER_27_502 VPWR VGND sg13cmos5l_decap_8
XFILLER_27_509 VPWR VGND sg13cmos5l_decap_4
XFILLER_28_230 VPWR VGND sg13cmos5l_decap_8
XFILLER_28_237 VPWR VGND sg13cmos5l_decap_8
XFILLER_28_244 VPWR VGND sg13cmos5l_decap_8
XFILLER_28_251 VPWR VGND sg13cmos5l_decap_8
XFILLER_28_258 VPWR VGND sg13cmos5l_decap_8
XFILLER_28_265 VPWR VGND sg13cmos5l_decap_8
XFILLER_28_272 VPWR VGND sg13cmos5l_decap_8
XFILLER_28_279 VPWR VGND sg13cmos5l_decap_8
XFILLER_28_286 VPWR VGND sg13cmos5l_decap_8
XFILLER_28_293 VPWR VGND sg13cmos5l_decap_8
XFILLER_28_300 VPWR VGND sg13cmos5l_decap_8
XFILLER_28_307 VPWR VGND sg13cmos5l_decap_8
XFILLER_28_314 VPWR VGND sg13cmos5l_decap_8
XFILLER_28_321 VPWR VGND sg13cmos5l_decap_8
XFILLER_28_328 VPWR VGND sg13cmos5l_decap_8
XFILLER_28_335 VPWR VGND sg13cmos5l_decap_8
XFILLER_28_342 VPWR VGND sg13cmos5l_decap_8
XFILLER_28_349 VPWR VGND sg13cmos5l_decap_8
XFILLER_28_356 VPWR VGND sg13cmos5l_decap_8
XFILLER_28_363 VPWR VGND sg13cmos5l_decap_8
XFILLER_28_370 VPWR VGND sg13cmos5l_decap_8
XFILLER_28_377 VPWR VGND sg13cmos5l_decap_8
XFILLER_28_384 VPWR VGND sg13cmos5l_decap_8
XFILLER_28_391 VPWR VGND sg13cmos5l_decap_8
XFILLER_28_398 VPWR VGND sg13cmos5l_decap_8
XFILLER_28_405 VPWR VGND sg13cmos5l_decap_8
XFILLER_28_412 VPWR VGND sg13cmos5l_decap_8
XFILLER_28_419 VPWR VGND sg13cmos5l_decap_8
XFILLER_28_426 VPWR VGND sg13cmos5l_decap_8
XFILLER_28_433 VPWR VGND sg13cmos5l_decap_8
XFILLER_28_440 VPWR VGND sg13cmos5l_decap_8
XFILLER_28_447 VPWR VGND sg13cmos5l_decap_8
XFILLER_28_454 VPWR VGND sg13cmos5l_decap_8
XFILLER_28_461 VPWR VGND sg13cmos5l_decap_8
XFILLER_28_468 VPWR VGND sg13cmos5l_decap_8
XFILLER_28_475 VPWR VGND sg13cmos5l_decap_8
XFILLER_28_482 VPWR VGND sg13cmos5l_decap_8
XFILLER_28_489 VPWR VGND sg13cmos5l_decap_8
XFILLER_28_496 VPWR VGND sg13cmos5l_decap_8
XFILLER_28_503 VPWR VGND sg13cmos5l_decap_8
XFILLER_29_230 VPWR VGND sg13cmos5l_decap_8
XFILLER_29_237 VPWR VGND sg13cmos5l_decap_8
XFILLER_29_244 VPWR VGND sg13cmos5l_decap_8
XFILLER_29_251 VPWR VGND sg13cmos5l_decap_8
XFILLER_29_258 VPWR VGND sg13cmos5l_decap_8
XFILLER_29_265 VPWR VGND sg13cmos5l_decap_8
XFILLER_29_272 VPWR VGND sg13cmos5l_decap_8
XFILLER_29_279 VPWR VGND sg13cmos5l_decap_8
XFILLER_29_286 VPWR VGND sg13cmos5l_decap_8
XFILLER_29_293 VPWR VGND sg13cmos5l_decap_8
XFILLER_29_300 VPWR VGND sg13cmos5l_decap_8
XFILLER_29_307 VPWR VGND sg13cmos5l_decap_8
XFILLER_29_314 VPWR VGND sg13cmos5l_decap_8
XFILLER_29_321 VPWR VGND sg13cmos5l_decap_8
XFILLER_29_328 VPWR VGND sg13cmos5l_decap_8
XFILLER_29_335 VPWR VGND sg13cmos5l_decap_8
XFILLER_29_342 VPWR VGND sg13cmos5l_decap_8
XFILLER_29_349 VPWR VGND sg13cmos5l_decap_8
XFILLER_29_356 VPWR VGND sg13cmos5l_decap_8
XFILLER_29_363 VPWR VGND sg13cmos5l_decap_8
XFILLER_29_370 VPWR VGND sg13cmos5l_decap_8
XFILLER_29_377 VPWR VGND sg13cmos5l_decap_8
XFILLER_29_384 VPWR VGND sg13cmos5l_decap_8
XFILLER_29_391 VPWR VGND sg13cmos5l_decap_8
XFILLER_29_398 VPWR VGND sg13cmos5l_decap_8
XFILLER_29_405 VPWR VGND sg13cmos5l_decap_8
XFILLER_29_412 VPWR VGND sg13cmos5l_decap_8
XFILLER_29_419 VPWR VGND sg13cmos5l_decap_8
XFILLER_29_426 VPWR VGND sg13cmos5l_decap_8
XFILLER_29_433 VPWR VGND sg13cmos5l_decap_8
XFILLER_29_440 VPWR VGND sg13cmos5l_decap_8
XFILLER_29_447 VPWR VGND sg13cmos5l_decap_8
XFILLER_29_454 VPWR VGND sg13cmos5l_decap_8
XFILLER_29_461 VPWR VGND sg13cmos5l_decap_8
XFILLER_29_468 VPWR VGND sg13cmos5l_decap_8
XFILLER_29_475 VPWR VGND sg13cmos5l_decap_8
XFILLER_29_482 VPWR VGND sg13cmos5l_decap_8
XFILLER_29_489 VPWR VGND sg13cmos5l_decap_8
XFILLER_29_496 VPWR VGND sg13cmos5l_decap_8
XFILLER_29_503 VPWR VGND sg13cmos5l_decap_8
XFILLER_30_4 VPWR VGND sg13cmos5l_decap_8
XFILLER_30_11 VPWR VGND sg13cmos5l_decap_8
XFILLER_30_18 VPWR VGND sg13cmos5l_decap_8
XFILLER_30_25 VPWR VGND sg13cmos5l_decap_8
XFILLER_30_32 VPWR VGND sg13cmos5l_decap_8
XFILLER_30_39 VPWR VGND sg13cmos5l_decap_8
XFILLER_30_46 VPWR VGND sg13cmos5l_decap_8
XFILLER_30_53 VPWR VGND sg13cmos5l_decap_4
XFILLER_30_107 VPWR VGND sg13cmos5l_decap_8
XFILLER_30_114 VPWR VGND sg13cmos5l_decap_8
XFILLER_30_121 VPWR VGND sg13cmos5l_decap_4
XFILLER_30_154 VPWR VGND sg13cmos5l_decap_8
XFILLER_30_161 VPWR VGND sg13cmos5l_decap_8
XFILLER_30_168 VPWR VGND sg13cmos5l_decap_8
XFILLER_30_175 VPWR VGND sg13cmos5l_decap_8
XFILLER_30_182 VPWR VGND sg13cmos5l_decap_8
XFILLER_30_189 VPWR VGND sg13cmos5l_decap_8
XFILLER_30_196 VPWR VGND sg13cmos5l_decap_8
XFILLER_30_203 VPWR VGND sg13cmos5l_decap_8
XFILLER_30_210 VPWR VGND sg13cmos5l_decap_8
XFILLER_30_217 VPWR VGND sg13cmos5l_decap_8
XFILLER_30_224 VPWR VGND sg13cmos5l_decap_8
XFILLER_30_231 VPWR VGND sg13cmos5l_decap_8
XFILLER_30_238 VPWR VGND sg13cmos5l_decap_8
XFILLER_30_245 VPWR VGND sg13cmos5l_decap_8
XFILLER_30_252 VPWR VGND sg13cmos5l_decap_8
XFILLER_30_259 VPWR VGND sg13cmos5l_decap_8
XFILLER_30_266 VPWR VGND sg13cmos5l_decap_8
XFILLER_30_273 VPWR VGND sg13cmos5l_decap_8
XFILLER_30_280 VPWR VGND sg13cmos5l_decap_8
XFILLER_30_287 VPWR VGND sg13cmos5l_decap_8
XFILLER_30_294 VPWR VGND sg13cmos5l_decap_8
XFILLER_30_301 VPWR VGND sg13cmos5l_decap_8
XFILLER_30_308 VPWR VGND sg13cmos5l_decap_8
XFILLER_30_315 VPWR VGND sg13cmos5l_decap_8
XFILLER_30_322 VPWR VGND sg13cmos5l_decap_8
XFILLER_30_329 VPWR VGND sg13cmos5l_decap_8
XFILLER_30_336 VPWR VGND sg13cmos5l_decap_8
XFILLER_30_343 VPWR VGND sg13cmos5l_decap_8
XFILLER_30_350 VPWR VGND sg13cmos5l_decap_8
XFILLER_30_357 VPWR VGND sg13cmos5l_decap_8
XFILLER_30_364 VPWR VGND sg13cmos5l_decap_8
XFILLER_30_371 VPWR VGND sg13cmos5l_decap_8
XFILLER_30_378 VPWR VGND sg13cmos5l_decap_8
XFILLER_30_385 VPWR VGND sg13cmos5l_decap_8
XFILLER_30_392 VPWR VGND sg13cmos5l_decap_8
XFILLER_30_399 VPWR VGND sg13cmos5l_decap_8
XFILLER_30_406 VPWR VGND sg13cmos5l_decap_8
XFILLER_30_413 VPWR VGND sg13cmos5l_decap_8
XFILLER_30_420 VPWR VGND sg13cmos5l_decap_8
XFILLER_30_427 VPWR VGND sg13cmos5l_decap_8
XFILLER_30_434 VPWR VGND sg13cmos5l_decap_8
XFILLER_30_441 VPWR VGND sg13cmos5l_decap_8
XFILLER_30_448 VPWR VGND sg13cmos5l_decap_8
XFILLER_30_455 VPWR VGND sg13cmos5l_decap_8
XFILLER_30_462 VPWR VGND sg13cmos5l_decap_8
XFILLER_30_469 VPWR VGND sg13cmos5l_decap_8
XFILLER_30_476 VPWR VGND sg13cmos5l_decap_8
XFILLER_30_483 VPWR VGND sg13cmos5l_decap_8
XFILLER_30_490 VPWR VGND sg13cmos5l_decap_8
XFILLER_30_497 VPWR VGND sg13cmos5l_decap_8
XFILLER_30_504 VPWR VGND sg13cmos5l_decap_8
XFILLER_31_0 VPWR VGND sg13cmos5l_decap_8
XFILLER_31_7 VPWR VGND sg13cmos5l_decap_8
XFILLER_31_14 VPWR VGND sg13cmos5l_decap_8
XFILLER_31_21 VPWR VGND sg13cmos5l_decap_8
XFILLER_31_28 VPWR VGND sg13cmos5l_decap_8
XFILLER_31_35 VPWR VGND sg13cmos5l_decap_8
XFILLER_31_42 VPWR VGND sg13cmos5l_decap_8
XFILLER_31_49 VPWR VGND sg13cmos5l_decap_4
XFILLER_31_95 VPWR VGND sg13cmos5l_decap_8
XFILLER_31_102 VPWR VGND sg13cmos5l_decap_8
XFILLER_31_109 VPWR VGND sg13cmos5l_decap_8
XFILLER_31_116 VPWR VGND sg13cmos5l_decap_8
XFILLER_31_126 VPWR VGND sg13cmos5l_decap_8
XFILLER_31_133 VPWR VGND sg13cmos5l_decap_8
XFILLER_31_140 VPWR VGND sg13cmos5l_decap_8
XFILLER_31_147 VPWR VGND sg13cmos5l_decap_8
XFILLER_31_154 VPWR VGND sg13cmos5l_decap_8
XFILLER_31_161 VPWR VGND sg13cmos5l_decap_8
XFILLER_31_168 VPWR VGND sg13cmos5l_decap_8
XFILLER_31_175 VPWR VGND sg13cmos5l_decap_8
XFILLER_31_182 VPWR VGND sg13cmos5l_decap_8
XFILLER_31_189 VPWR VGND sg13cmos5l_decap_8
XFILLER_31_196 VPWR VGND sg13cmos5l_decap_8
XFILLER_31_203 VPWR VGND sg13cmos5l_decap_8
XFILLER_31_210 VPWR VGND sg13cmos5l_decap_8
XFILLER_31_217 VPWR VGND sg13cmos5l_decap_8
XFILLER_31_224 VPWR VGND sg13cmos5l_decap_8
XFILLER_31_231 VPWR VGND sg13cmos5l_decap_8
XFILLER_31_238 VPWR VGND sg13cmos5l_decap_8
XFILLER_31_245 VPWR VGND sg13cmos5l_decap_8
XFILLER_31_252 VPWR VGND sg13cmos5l_decap_8
XFILLER_31_259 VPWR VGND sg13cmos5l_decap_8
XFILLER_31_266 VPWR VGND sg13cmos5l_decap_8
XFILLER_31_273 VPWR VGND sg13cmos5l_decap_8
XFILLER_31_280 VPWR VGND sg13cmos5l_decap_8
XFILLER_31_287 VPWR VGND sg13cmos5l_decap_8
XFILLER_31_294 VPWR VGND sg13cmos5l_decap_8
XFILLER_31_301 VPWR VGND sg13cmos5l_decap_8
XFILLER_31_308 VPWR VGND sg13cmos5l_decap_8
XFILLER_31_315 VPWR VGND sg13cmos5l_decap_8
XFILLER_31_322 VPWR VGND sg13cmos5l_decap_8
XFILLER_31_329 VPWR VGND sg13cmos5l_decap_8
XFILLER_31_336 VPWR VGND sg13cmos5l_decap_8
XFILLER_31_343 VPWR VGND sg13cmos5l_decap_8
XFILLER_31_350 VPWR VGND sg13cmos5l_decap_8
XFILLER_31_357 VPWR VGND sg13cmos5l_decap_8
XFILLER_31_364 VPWR VGND sg13cmos5l_decap_8
XFILLER_31_371 VPWR VGND sg13cmos5l_decap_8
XFILLER_31_378 VPWR VGND sg13cmos5l_decap_8
XFILLER_31_385 VPWR VGND sg13cmos5l_decap_8
XFILLER_31_392 VPWR VGND sg13cmos5l_decap_8
XFILLER_31_399 VPWR VGND sg13cmos5l_decap_8
XFILLER_31_406 VPWR VGND sg13cmos5l_decap_8
XFILLER_31_413 VPWR VGND sg13cmos5l_decap_8
XFILLER_31_420 VPWR VGND sg13cmos5l_decap_8
XFILLER_31_427 VPWR VGND sg13cmos5l_decap_8
XFILLER_31_434 VPWR VGND sg13cmos5l_decap_8
XFILLER_31_441 VPWR VGND sg13cmos5l_decap_8
XFILLER_31_448 VPWR VGND sg13cmos5l_decap_8
XFILLER_31_455 VPWR VGND sg13cmos5l_decap_8
XFILLER_31_462 VPWR VGND sg13cmos5l_decap_8
XFILLER_31_469 VPWR VGND sg13cmos5l_decap_8
XFILLER_31_476 VPWR VGND sg13cmos5l_decap_8
XFILLER_31_483 VPWR VGND sg13cmos5l_decap_8
XFILLER_31_490 VPWR VGND sg13cmos5l_decap_8
XFILLER_31_497 VPWR VGND sg13cmos5l_decap_8
XFILLER_31_504 VPWR VGND sg13cmos5l_decap_8
XFILLER_32_0 VPWR VGND sg13cmos5l_decap_8
XFILLER_32_7 VPWR VGND sg13cmos5l_decap_8
XFILLER_32_14 VPWR VGND sg13cmos5l_decap_8
XFILLER_32_21 VPWR VGND sg13cmos5l_decap_8
XFILLER_32_28 VPWR VGND sg13cmos5l_decap_8
XFILLER_32_35 VPWR VGND sg13cmos5l_decap_8
XFILLER_32_42 VPWR VGND sg13cmos5l_decap_8
XFILLER_32_49 VPWR VGND sg13cmos5l_decap_8
XFILLER_32_56 VPWR VGND sg13cmos5l_decap_8
XFILLER_32_63 VPWR VGND sg13cmos5l_decap_8
XFILLER_32_70 VPWR VGND sg13cmos5l_decap_4
XFILLER_32_83 VPWR VGND sg13cmos5l_decap_8
XFILLER_32_90 VPWR VGND sg13cmos5l_decap_8
XFILLER_32_97 VPWR VGND sg13cmos5l_decap_8
XFILLER_32_104 VPWR VGND sg13cmos5l_decap_8
XFILLER_32_111 VPWR VGND sg13cmos5l_decap_8
XFILLER_32_118 VPWR VGND sg13cmos5l_decap_8
XFILLER_32_125 VPWR VGND sg13cmos5l_decap_8
XFILLER_32_132 VPWR VGND sg13cmos5l_decap_8
XFILLER_32_139 VPWR VGND sg13cmos5l_decap_8
XFILLER_32_146 VPWR VGND sg13cmos5l_decap_8
XFILLER_32_153 VPWR VGND sg13cmos5l_decap_8
XFILLER_32_160 VPWR VGND sg13cmos5l_decap_8
XFILLER_32_167 VPWR VGND sg13cmos5l_decap_8
XFILLER_32_174 VPWR VGND sg13cmos5l_decap_8
XFILLER_32_181 VPWR VGND sg13cmos5l_decap_8
XFILLER_32_188 VPWR VGND sg13cmos5l_decap_8
XFILLER_32_195 VPWR VGND sg13cmos5l_decap_8
XFILLER_32_202 VPWR VGND sg13cmos5l_decap_8
XFILLER_32_209 VPWR VGND sg13cmos5l_decap_8
XFILLER_32_216 VPWR VGND sg13cmos5l_decap_8
XFILLER_32_223 VPWR VGND sg13cmos5l_decap_8
XFILLER_32_230 VPWR VGND sg13cmos5l_decap_8
XFILLER_32_237 VPWR VGND sg13cmos5l_decap_8
XFILLER_32_244 VPWR VGND sg13cmos5l_decap_8
XFILLER_32_251 VPWR VGND sg13cmos5l_decap_8
XFILLER_32_258 VPWR VGND sg13cmos5l_decap_8
XFILLER_32_265 VPWR VGND sg13cmos5l_decap_8
XFILLER_32_272 VPWR VGND sg13cmos5l_decap_8
XFILLER_32_279 VPWR VGND sg13cmos5l_decap_8
XFILLER_32_286 VPWR VGND sg13cmos5l_decap_8
XFILLER_32_293 VPWR VGND sg13cmos5l_decap_8
XFILLER_32_300 VPWR VGND sg13cmos5l_decap_8
XFILLER_32_307 VPWR VGND sg13cmos5l_decap_8
XFILLER_32_314 VPWR VGND sg13cmos5l_decap_8
XFILLER_32_321 VPWR VGND sg13cmos5l_decap_8
XFILLER_32_328 VPWR VGND sg13cmos5l_decap_8
XFILLER_32_335 VPWR VGND sg13cmos5l_decap_8
XFILLER_32_342 VPWR VGND sg13cmos5l_decap_8
XFILLER_32_349 VPWR VGND sg13cmos5l_decap_8
XFILLER_32_356 VPWR VGND sg13cmos5l_decap_8
XFILLER_32_363 VPWR VGND sg13cmos5l_decap_8
XFILLER_32_370 VPWR VGND sg13cmos5l_decap_8
XFILLER_32_377 VPWR VGND sg13cmos5l_decap_8
XFILLER_32_384 VPWR VGND sg13cmos5l_decap_8
XFILLER_32_391 VPWR VGND sg13cmos5l_decap_8
XFILLER_32_398 VPWR VGND sg13cmos5l_decap_8
XFILLER_32_405 VPWR VGND sg13cmos5l_decap_8
XFILLER_32_412 VPWR VGND sg13cmos5l_decap_8
XFILLER_32_419 VPWR VGND sg13cmos5l_decap_8
XFILLER_32_426 VPWR VGND sg13cmos5l_decap_8
XFILLER_32_433 VPWR VGND sg13cmos5l_decap_8
XFILLER_32_440 VPWR VGND sg13cmos5l_decap_8
XFILLER_32_447 VPWR VGND sg13cmos5l_decap_8
XFILLER_32_454 VPWR VGND sg13cmos5l_decap_8
XFILLER_32_461 VPWR VGND sg13cmos5l_decap_8
XFILLER_32_468 VPWR VGND sg13cmos5l_decap_8
XFILLER_32_475 VPWR VGND sg13cmos5l_decap_8
XFILLER_32_482 VPWR VGND sg13cmos5l_decap_8
XFILLER_32_489 VPWR VGND sg13cmos5l_decap_8
XFILLER_33_0 VPWR VGND sg13cmos5l_decap_8
XFILLER_33_7 VPWR VGND sg13cmos5l_decap_8
XFILLER_33_14 VPWR VGND sg13cmos5l_decap_8
XFILLER_33_21 VPWR VGND sg13cmos5l_decap_8
XFILLER_33_28 VPWR VGND sg13cmos5l_decap_8
XFILLER_33_35 VPWR VGND sg13cmos5l_decap_8
XFILLER_33_42 VPWR VGND sg13cmos5l_decap_8
XFILLER_33_49 VPWR VGND sg13cmos5l_decap_8
XFILLER_33_56 VPWR VGND sg13cmos5l_decap_8
XFILLER_33_63 VPWR VGND sg13cmos5l_decap_8
XFILLER_33_70 VPWR VGND sg13cmos5l_decap_8
XFILLER_33_77 VPWR VGND sg13cmos5l_decap_8
XFILLER_33_84 VPWR VGND sg13cmos5l_decap_8
XFILLER_33_91 VPWR VGND sg13cmos5l_decap_8
XFILLER_33_98 VPWR VGND sg13cmos5l_decap_8
XFILLER_33_105 VPWR VGND sg13cmos5l_decap_8
XFILLER_33_112 VPWR VGND sg13cmos5l_decap_8
XFILLER_33_125 VPWR VGND sg13cmos5l_decap_8
XFILLER_33_132 VPWR VGND sg13cmos5l_decap_8
XFILLER_33_144 VPWR VGND sg13cmos5l_decap_8
XFILLER_33_151 VPWR VGND sg13cmos5l_decap_8
XFILLER_33_158 VPWR VGND sg13cmos5l_decap_8
XFILLER_33_165 VPWR VGND sg13cmos5l_decap_8
XFILLER_33_172 VPWR VGND sg13cmos5l_decap_8
XFILLER_33_179 VPWR VGND sg13cmos5l_decap_8
XFILLER_33_186 VPWR VGND sg13cmos5l_decap_8
XFILLER_33_193 VPWR VGND sg13cmos5l_decap_8
XFILLER_33_200 VPWR VGND sg13cmos5l_decap_8
XFILLER_33_207 VPWR VGND sg13cmos5l_decap_8
XFILLER_33_214 VPWR VGND sg13cmos5l_decap_8
XFILLER_33_221 VPWR VGND sg13cmos5l_decap_8
XFILLER_33_228 VPWR VGND sg13cmos5l_decap_8
XFILLER_33_235 VPWR VGND sg13cmos5l_decap_8
XFILLER_33_242 VPWR VGND sg13cmos5l_decap_8
XFILLER_33_249 VPWR VGND sg13cmos5l_decap_8
XFILLER_33_256 VPWR VGND sg13cmos5l_decap_8
XFILLER_33_263 VPWR VGND sg13cmos5l_decap_8
XFILLER_33_270 VPWR VGND sg13cmos5l_decap_8
XFILLER_33_277 VPWR VGND sg13cmos5l_decap_8
XFILLER_33_284 VPWR VGND sg13cmos5l_decap_8
XFILLER_33_291 VPWR VGND sg13cmos5l_decap_8
XFILLER_33_298 VPWR VGND sg13cmos5l_decap_8
XFILLER_33_305 VPWR VGND sg13cmos5l_decap_8
XFILLER_33_312 VPWR VGND sg13cmos5l_decap_8
XFILLER_33_319 VPWR VGND sg13cmos5l_decap_8
XFILLER_33_326 VPWR VGND sg13cmos5l_decap_8
XFILLER_33_333 VPWR VGND sg13cmos5l_decap_8
XFILLER_33_340 VPWR VGND sg13cmos5l_decap_8
XFILLER_33_347 VPWR VGND sg13cmos5l_decap_8
XFILLER_33_354 VPWR VGND sg13cmos5l_decap_8
XFILLER_33_361 VPWR VGND sg13cmos5l_decap_8
XFILLER_33_368 VPWR VGND sg13cmos5l_decap_8
XFILLER_33_375 VPWR VGND sg13cmos5l_decap_8
XFILLER_33_382 VPWR VGND sg13cmos5l_decap_8
XFILLER_33_389 VPWR VGND sg13cmos5l_decap_8
XFILLER_33_396 VPWR VGND sg13cmos5l_decap_8
XFILLER_33_403 VPWR VGND sg13cmos5l_decap_8
XFILLER_33_410 VPWR VGND sg13cmos5l_decap_8
XFILLER_33_417 VPWR VGND sg13cmos5l_decap_8
XFILLER_33_424 VPWR VGND sg13cmos5l_decap_8
XFILLER_33_431 VPWR VGND sg13cmos5l_decap_8
XFILLER_33_438 VPWR VGND sg13cmos5l_decap_8
XFILLER_33_445 VPWR VGND sg13cmos5l_decap_8
XFILLER_33_452 VPWR VGND sg13cmos5l_decap_8
XFILLER_33_459 VPWR VGND sg13cmos5l_decap_8
XFILLER_33_466 VPWR VGND sg13cmos5l_decap_8
XFILLER_33_473 VPWR VGND sg13cmos5l_decap_8
XFILLER_33_480 VPWR VGND sg13cmos5l_decap_8
XFILLER_33_487 VPWR VGND sg13cmos5l_decap_4
XFILLER_34_0 VPWR VGND sg13cmos5l_decap_8
XFILLER_34_7 VPWR VGND sg13cmos5l_decap_8
XFILLER_34_14 VPWR VGND sg13cmos5l_decap_8
XFILLER_34_21 VPWR VGND sg13cmos5l_decap_8
XFILLER_34_28 VPWR VGND sg13cmos5l_decap_8
XFILLER_34_35 VPWR VGND sg13cmos5l_decap_8
XFILLER_34_42 VPWR VGND sg13cmos5l_decap_8
XFILLER_34_49 VPWR VGND sg13cmos5l_decap_8
XFILLER_34_56 VPWR VGND sg13cmos5l_decap_8
XFILLER_34_63 VPWR VGND sg13cmos5l_decap_8
XFILLER_34_70 VPWR VGND sg13cmos5l_decap_8
XFILLER_34_77 VPWR VGND sg13cmos5l_decap_8
XFILLER_34_84 VPWR VGND sg13cmos5l_decap_8
XFILLER_34_91 VPWR VGND sg13cmos5l_decap_8
XFILLER_34_98 VPWR VGND sg13cmos5l_decap_8
XFILLER_34_105 VPWR VGND sg13cmos5l_decap_8
XFILLER_34_112 VPWR VGND sg13cmos5l_decap_8
XFILLER_34_119 VPWR VGND sg13cmos5l_decap_8
XFILLER_34_126 VPWR VGND sg13cmos5l_decap_8
XFILLER_34_133 VPWR VGND sg13cmos5l_decap_8
XFILLER_34_140 VPWR VGND sg13cmos5l_decap_8
XFILLER_34_147 VPWR VGND sg13cmos5l_decap_8
XFILLER_34_154 VPWR VGND sg13cmos5l_decap_8
XFILLER_34_161 VPWR VGND sg13cmos5l_decap_8
XFILLER_34_168 VPWR VGND sg13cmos5l_decap_8
XFILLER_34_175 VPWR VGND sg13cmos5l_decap_8
XFILLER_34_182 VPWR VGND sg13cmos5l_decap_8
XFILLER_34_189 VPWR VGND sg13cmos5l_decap_8
XFILLER_34_196 VPWR VGND sg13cmos5l_decap_8
XFILLER_34_203 VPWR VGND sg13cmos5l_decap_8
XFILLER_34_210 VPWR VGND sg13cmos5l_decap_8
XFILLER_34_217 VPWR VGND sg13cmos5l_decap_8
XFILLER_34_224 VPWR VGND sg13cmos5l_decap_8
XFILLER_34_231 VPWR VGND sg13cmos5l_decap_4
XFILLER_35_0 VPWR VGND sg13cmos5l_decap_8
XFILLER_35_7 VPWR VGND sg13cmos5l_decap_8
XFILLER_35_14 VPWR VGND sg13cmos5l_decap_8
XFILLER_35_21 VPWR VGND sg13cmos5l_decap_8
XFILLER_35_28 VPWR VGND sg13cmos5l_decap_8
XFILLER_35_35 VPWR VGND sg13cmos5l_decap_8
XFILLER_35_42 VPWR VGND sg13cmos5l_decap_8
XFILLER_35_49 VPWR VGND sg13cmos5l_decap_8
XFILLER_35_56 VPWR VGND sg13cmos5l_decap_8
XFILLER_35_63 VPWR VGND sg13cmos5l_decap_8
XFILLER_35_70 VPWR VGND sg13cmos5l_decap_8
XFILLER_35_77 VPWR VGND sg13cmos5l_decap_8
XFILLER_35_84 VPWR VGND sg13cmos5l_decap_8
XFILLER_35_91 VPWR VGND sg13cmos5l_decap_8
XFILLER_35_98 VPWR VGND sg13cmos5l_decap_8
XFILLER_35_105 VPWR VGND sg13cmos5l_decap_8
XFILLER_35_112 VPWR VGND sg13cmos5l_decap_8
XFILLER_35_119 VPWR VGND sg13cmos5l_decap_8
XFILLER_35_126 VPWR VGND sg13cmos5l_decap_8
XFILLER_35_133 VPWR VGND sg13cmos5l_decap_8
XFILLER_35_140 VPWR VGND sg13cmos5l_decap_8
XFILLER_35_147 VPWR VGND sg13cmos5l_decap_8
XFILLER_35_154 VPWR VGND sg13cmos5l_decap_8
XFILLER_35_161 VPWR VGND sg13cmos5l_decap_8
XFILLER_35_168 VPWR VGND sg13cmos5l_decap_8
XFILLER_35_175 VPWR VGND sg13cmos5l_decap_8
XFILLER_35_182 VPWR VGND sg13cmos5l_decap_8
XFILLER_35_189 VPWR VGND sg13cmos5l_decap_8
XFILLER_35_196 VPWR VGND sg13cmos5l_decap_8
XFILLER_35_203 VPWR VGND sg13cmos5l_decap_8
XFILLER_35_210 VPWR VGND sg13cmos5l_decap_8
XFILLER_35_217 VPWR VGND sg13cmos5l_decap_8
XFILLER_35_224 VPWR VGND sg13cmos5l_decap_8
XFILLER_35_231 VPWR VGND sg13cmos5l_decap_4
XFILLER_36_0 VPWR VGND sg13cmos5l_decap_8
XFILLER_36_7 VPWR VGND sg13cmos5l_decap_8
XFILLER_36_14 VPWR VGND sg13cmos5l_decap_8
XFILLER_36_21 VPWR VGND sg13cmos5l_decap_8
XFILLER_36_28 VPWR VGND sg13cmos5l_decap_8
XFILLER_36_35 VPWR VGND sg13cmos5l_decap_8
XFILLER_36_42 VPWR VGND sg13cmos5l_decap_8
XFILLER_36_49 VPWR VGND sg13cmos5l_decap_8
XFILLER_36_56 VPWR VGND sg13cmos5l_decap_8
XFILLER_36_63 VPWR VGND sg13cmos5l_decap_8
XFILLER_36_70 VPWR VGND sg13cmos5l_decap_8
XFILLER_36_77 VPWR VGND sg13cmos5l_decap_8
XFILLER_36_84 VPWR VGND sg13cmos5l_decap_8
XFILLER_36_91 VPWR VGND sg13cmos5l_decap_8
XFILLER_36_98 VPWR VGND sg13cmos5l_decap_8
XFILLER_36_105 VPWR VGND sg13cmos5l_decap_8
XFILLER_36_112 VPWR VGND sg13cmos5l_decap_8
XFILLER_36_119 VPWR VGND sg13cmos5l_decap_8
XFILLER_36_126 VPWR VGND sg13cmos5l_decap_8
XFILLER_36_133 VPWR VGND sg13cmos5l_decap_8
XFILLER_36_140 VPWR VGND sg13cmos5l_decap_8
XFILLER_36_147 VPWR VGND sg13cmos5l_decap_8
XFILLER_36_154 VPWR VGND sg13cmos5l_decap_8
XFILLER_36_161 VPWR VGND sg13cmos5l_decap_8
XFILLER_36_168 VPWR VGND sg13cmos5l_decap_8
XFILLER_36_175 VPWR VGND sg13cmos5l_decap_8
XFILLER_36_182 VPWR VGND sg13cmos5l_decap_8
XFILLER_36_189 VPWR VGND sg13cmos5l_decap_8
XFILLER_36_196 VPWR VGND sg13cmos5l_decap_8
XFILLER_36_203 VPWR VGND sg13cmos5l_decap_8
XFILLER_36_210 VPWR VGND sg13cmos5l_decap_8
XFILLER_36_217 VPWR VGND sg13cmos5l_decap_8
XFILLER_36_224 VPWR VGND sg13cmos5l_decap_8
XFILLER_36_231 VPWR VGND sg13cmos5l_decap_4
XFILLER_37_0 VPWR VGND sg13cmos5l_decap_8
XFILLER_37_7 VPWR VGND sg13cmos5l_decap_8
XFILLER_37_14 VPWR VGND sg13cmos5l_decap_8
XFILLER_37_21 VPWR VGND sg13cmos5l_decap_8
XFILLER_37_28 VPWR VGND sg13cmos5l_decap_8
XFILLER_37_35 VPWR VGND sg13cmos5l_decap_8
XFILLER_37_42 VPWR VGND sg13cmos5l_decap_8
XFILLER_37_49 VPWR VGND sg13cmos5l_decap_8
XFILLER_37_56 VPWR VGND sg13cmos5l_decap_8
XFILLER_37_63 VPWR VGND sg13cmos5l_decap_8
XFILLER_37_70 VPWR VGND sg13cmos5l_decap_8
XFILLER_37_77 VPWR VGND sg13cmos5l_decap_8
XFILLER_37_84 VPWR VGND sg13cmos5l_decap_8
XFILLER_37_91 VPWR VGND sg13cmos5l_decap_8
XFILLER_37_98 VPWR VGND sg13cmos5l_decap_8
XFILLER_37_105 VPWR VGND sg13cmos5l_decap_8
XFILLER_37_112 VPWR VGND sg13cmos5l_decap_8
XFILLER_37_119 VPWR VGND sg13cmos5l_decap_8
XFILLER_37_126 VPWR VGND sg13cmos5l_decap_8
XFILLER_37_133 VPWR VGND sg13cmos5l_decap_8
XFILLER_37_140 VPWR VGND sg13cmos5l_decap_8
XFILLER_37_147 VPWR VGND sg13cmos5l_decap_8
XFILLER_37_154 VPWR VGND sg13cmos5l_decap_8
XFILLER_37_161 VPWR VGND sg13cmos5l_decap_8
XFILLER_37_168 VPWR VGND sg13cmos5l_decap_8
XFILLER_37_175 VPWR VGND sg13cmos5l_decap_8
XFILLER_37_182 VPWR VGND sg13cmos5l_decap_8
XFILLER_37_189 VPWR VGND sg13cmos5l_decap_8
XFILLER_37_196 VPWR VGND sg13cmos5l_decap_8
XFILLER_37_203 VPWR VGND sg13cmos5l_decap_8
XFILLER_37_210 VPWR VGND sg13cmos5l_decap_8
XFILLER_37_217 VPWR VGND sg13cmos5l_decap_8
XFILLER_37_224 VPWR VGND sg13cmos5l_decap_8
XFILLER_37_231 VPWR VGND sg13cmos5l_decap_4
XFILLER_38_4 VPWR VGND sg13cmos5l_decap_8
XFILLER_38_11 VPWR VGND sg13cmos5l_decap_8
XFILLER_38_18 VPWR VGND sg13cmos5l_decap_8
XFILLER_38_25 VPWR VGND sg13cmos5l_decap_8
XFILLER_38_32 VPWR VGND sg13cmos5l_decap_8
XFILLER_38_39 VPWR VGND sg13cmos5l_decap_8
XFILLER_38_46 VPWR VGND sg13cmos5l_decap_8
XFILLER_38_53 VPWR VGND sg13cmos5l_decap_8
XFILLER_38_60 VPWR VGND sg13cmos5l_decap_8
XFILLER_38_67 VPWR VGND sg13cmos5l_decap_8
XFILLER_38_74 VPWR VGND sg13cmos5l_decap_8
XFILLER_38_81 VPWR VGND sg13cmos5l_decap_8
XFILLER_38_88 VPWR VGND sg13cmos5l_decap_8
XFILLER_38_95 VPWR VGND sg13cmos5l_decap_8
XFILLER_38_102 VPWR VGND sg13cmos5l_decap_8
XFILLER_38_109 VPWR VGND sg13cmos5l_decap_8
XFILLER_38_116 VPWR VGND sg13cmos5l_decap_8
XFILLER_38_123 VPWR VGND sg13cmos5l_decap_8
XFILLER_38_130 VPWR VGND sg13cmos5l_decap_8
XFILLER_38_137 VPWR VGND sg13cmos5l_decap_8
XFILLER_38_144 VPWR VGND sg13cmos5l_decap_8
XFILLER_38_151 VPWR VGND sg13cmos5l_decap_8
XFILLER_38_158 VPWR VGND sg13cmos5l_decap_8
XFILLER_38_165 VPWR VGND sg13cmos5l_decap_8
XFILLER_38_172 VPWR VGND sg13cmos5l_decap_8
XFILLER_38_179 VPWR VGND sg13cmos5l_decap_8
XFILLER_38_186 VPWR VGND sg13cmos5l_decap_8
XFILLER_38_193 VPWR VGND sg13cmos5l_decap_8
XFILLER_38_200 VPWR VGND sg13cmos5l_decap_8
XFILLER_38_207 VPWR VGND sg13cmos5l_decap_8
XFILLER_38_214 VPWR VGND sg13cmos5l_decap_8
XFILLER_38_221 VPWR VGND sg13cmos5l_decap_8
XFILLER_38_228 VPWR VGND sg13cmos5l_decap_8
.ENDS mdll

* ===== build/sg13cmos5l/macros/clk_gen/cdl/clk_gen.cdl
* CDL Netlist generated by OpenROAD

*.BUSDELIMITER [

.SUBCKT clk_gen C[0] C[1] C[2] C[3] C[4] C[5] C[6] C[7] Resetb  clk_out clk_ref div sel VPWR VGND
Xx1.x1 M_out x1.ring_n clk_refb sel_i VPWR VGND sg13cmos5l_mux2_2
Xx1.x10 ring_out x1.net12 VPWR VGND sg13cmos5l_inv_16
Xx1.x6.xcob7_36 net38 VPWR VGND sg13cmos5l_tielo
Xx4.x2_37 net39 VPWR VGND sg13cmos5l_tielo
Xx1.x11._041_ x1.co0\[0\] x1.x11.g_en\[0\].first.u_e.a net18  VPWR VGND sg13cmos5l_or2_1
Xx1.x11._042_ x1.co1\[1\] net21 x1.x11.g_en\[10\].rest.u_e.c  x1.x11.g_en\[10\].rest.u_e.a VPWR VGND sg13cmos5l_a21o_1
Xx1.x11._043_ x1.cob1\[1\] net21 x1.x11.g_en\[10\].rest.u_e.a  x1.x11.g_en\[11\].rest.u_e.a VPWR VGND sg13cmos5l_a21o_1
Xx1.x11._044_ x1.co2\[1\] net21 x1.x11.g_en\[11\].rest.u_e.a  x1.x11.g_en\[12\].rest.u_e.a VPWR VGND sg13cmos5l_a21o_1
Xx1.x11._045_ x1.cob2\[1\] net22 x1.x11.g_en\[12\].rest.u_e.a  x1.x11.g_en\[13\].rest.u_e.a VPWR VGND sg13cmos5l_a21o_1
Xx1.x11._046_ x1.co3\[1\] net15 x1.x11.g_en\[13\].rest.u_e.a  x1.x11.g_en\[14\].rest.u_e.a VPWR VGND sg13cmos5l_a21o_1
Xx1.x11._047_ x1.cob3\[1\] net13 x1.x11.g_en\[14\].rest.u_e.a  x1.x11.g_en\[15\].rest.u_e.a VPWR VGND sg13cmos5l_a21o_1
Xx1.x11._048_ x1.co0\[2\] net19 x1.x11.g_en\[15\].rest.u_e.a  x1.x11.g_en\[16\].rest.u_e.a VPWR VGND sg13cmos5l_a21o_1
Xx1.x11._049_ x1.cob0\[2\] net19 x1.x11.g_en\[16\].rest.u_e.a  x1.x11.g_en\[17\].rest.u_e.a VPWR VGND sg13cmos5l_a21o_1
Xx1.x11._050_ x1.co1\[2\] net22 x1.x11.g_en\[17\].rest.u_e.a  x1.x11.g_en\[18\].rest.u_e.a VPWR VGND sg13cmos5l_a21o_1
Xx1.x11._051_ x1.cob1\[2\] net14 x1.x11.g_en\[18\].rest.u_e.a  x1.x11.g_en\[19\].rest.u_e.a VPWR VGND sg13cmos5l_a21o_1
Xx1.x11._052_ x1.cob0\[0\] net18 x1.x11.g_en\[0\].first.u_e.a  x1.x11.g_en\[1\].rest.u_e.a VPWR VGND sg13cmos5l_a21o_1
Xx1.x11._053_ x1.co2\[2\] net14 x1.x11.g_en\[19\].rest.u_e.a  x1.x11.g_en\[20\].rest.u_e.a VPWR VGND sg13cmos5l_a21o_1
Xx1.x11._054_ x1.cob2\[2\] net14 x1.x11.g_en\[20\].rest.u_e.a  x1.x11.g_en\[21\].rest.u_e.a VPWR VGND sg13cmos5l_a21o_1
Xx1.x11._055_ x1.co3\[2\] net14 x1.x11.g_en\[21\].rest.u_e.a  x1.x11.g_en\[22\].rest.u_e.a VPWR VGND sg13cmos5l_a21o_1
Xx1.x11._056_ x1.cob3\[2\] net13 x1.x11.g_en\[22\].rest.u_e.a  x1.x11.g_en\[23\].rest.u_e.a VPWR VGND sg13cmos5l_a21o_1
Xx1.x11._057_ x1.co0\[3\] net13 x1.x11.g_en\[23\].rest.u_e.a  x1.x11.g_en\[24\].rest.u_e.a VPWR VGND sg13cmos5l_a21o_1
Xx1.x11._058_ x1.cob0\[3\] net19 x1.x11.g_en\[24\].rest.u_e.a  x1.x11.g_en\[25\].rest.u_e.a VPWR VGND sg13cmos5l_a21o_1
Xx1.x11._059_ x1.co1\[3\] net19 x1.x11.g_en\[25\].rest.u_e.a  x1.x11.g_en\[26\].rest.u_e.a VPWR VGND sg13cmos5l_a21o_1
Xx1.x11._060_ x1.cob1\[3\] net13 x1.x11.g_en\[26\].rest.u_e.a  x1.x11.g_en\[27\].rest.u_e.a VPWR VGND sg13cmos5l_a21o_1
Xx1.x11._061_ x1.co2\[3\] net14 x1.x11.g_en\[27\].rest.u_e.a  x1.x11.g_en\[28\].rest.u_e.a VPWR VGND sg13cmos5l_a21o_1
Xx1.x11._062_ x1.cob2\[3\] net14 x1.x11.g_en\[28\].rest.u_e.a  x1.x11.g_en\[29\].rest.u_e.a VPWR VGND sg13cmos5l_a21o_1
Xx1.x11._063_ x1.co1\[0\] net18 x1.x11.g_en\[1\].rest.u_e.a  x1.x11.g_en\[2\].rest.u_e.a VPWR VGND sg13cmos5l_a21o_1
Xx1.x11._064_ x1.co3\[3\] net14 x1.x11.g_en\[29\].rest.u_e.a  x1.x11.g_en\[30\].rest.u_e.a VPWR VGND sg13cmos5l_a21o_1
Xx1.x11._065_ x1.cob3\[3\] net14 x1.x11.g_en\[30\].rest.u_e.a  net32 VPWR VGND sg13cmos5l_a21o_1
Xx1.x11._066_ x1.co0\[4\] net19 net31 x1.x11.g_en\[32\].rest.u_e.a  VPWR VGND sg13cmos5l_a21o_1
Xx1.x11._067_ x1.cob0\[4\] net18 x1.x11.g_en\[32\].rest.u_e.a  x1.x11.g_en\[33\].rest.u_e.a VPWR VGND sg13cmos5l_a21o_1
Xx1.x11._068_ x1.co1\[4\] net20 x1.x11.g_en\[33\].rest.u_e.a  x1.x11.g_en\[34\].rest.u_e.a VPWR VGND sg13cmos5l_a21o_1
Xx1.x11._069_ x1.cob1\[4\] net21 x1.x11.g_en\[34\].rest.u_e.a  x1.x11.g_en\[35\].rest.u_e.a VPWR VGND sg13cmos5l_a21o_1
Xx1.x11._070_ x1.co2\[4\] net15 x1.x11.g_en\[35\].rest.u_e.a  x1.x11.g_en\[36\].rest.u_e.a VPWR VGND sg13cmos5l_a21o_1
Xx1.x11._071_ x1.cob2\[4\] net15 x1.x11.g_en\[36\].rest.u_e.a  x1.x11.g_en\[37\].rest.u_e.a VPWR VGND sg13cmos5l_a21o_1
Xx1.x11._072_ x1.co3\[4\] net15 x1.x11.g_en\[37\].rest.u_e.a  x1.x11.g_en\[38\].rest.u_e.a VPWR VGND sg13cmos5l_a21o_1
Xx1.x11._073_ x1.cob3\[4\] net13 x1.x11.g_en\[38\].rest.u_e.a  x1.x11.g_en\[39\].rest.u_e.a VPWR VGND sg13cmos5l_a21o_1
Xx1.x11._074_ x1.cob1\[0\] net21 x1.x11.g_en\[2\].rest.u_e.a  x1.x11.g_en\[3\].rest.u_e.a VPWR VGND sg13cmos5l_a21o_1
Xx1.x11._075_ x1.co0\[5\] net18 x1.x11.g_en\[39\].rest.u_e.a  x1.x11.g_en\[40\].rest.u_e.a VPWR VGND sg13cmos5l_a21o_1
Xx1.x11._076_ x1.cob0\[5\] net18 x1.x11.g_en\[40\].rest.u_e.a  x1.x11.g_en\[41\].rest.u_e.a VPWR VGND sg13cmos5l_a21o_1
Xx1.x11._077_ x1.co1\[5\] net20 x1.x11.g_en\[41\].rest.u_e.a  x1.x11.g_en\[42\].rest.u_e.a VPWR VGND sg13cmos5l_a21o_1
Xx1.x11._078_ x1.cob1\[5\] net21 x1.x11.g_en\[42\].rest.u_e.a  x1.x11.g_en\[43\].rest.u_e.a VPWR VGND sg13cmos5l_a21o_1
Xx1.x11._079_ x1.co2\[5\] net21 x1.x11.g_en\[43\].rest.u_e.a  x1.x11.g_en\[44\].rest.u_e.a VPWR VGND sg13cmos5l_a21o_1
Xx1.x11._080_ x1.cob2\[5\] net22 x1.x11.g_en\[44\].rest.u_e.a  x1.x11.g_en\[45\].rest.u_e.a VPWR VGND sg13cmos5l_a21o_1
Xx1.x11._081_ x1.co3\[5\] net16 x1.x11.g_en\[45\].rest.u_e.a  x1.x11.g_en\[46\].rest.u_e.a VPWR VGND sg13cmos5l_a21o_1
Xx1.x11._082_ x1.cob3\[5\] net13 x1.x11.g_en\[46\].rest.u_e.a  x1.x11.g_en\[47\].rest.u_e.a VPWR VGND sg13cmos5l_a21o_1
Xx1.x11._083_ x1.co0\[6\] net13 x1.x11.g_en\[47\].rest.u_e.a  x1.x11.g_en\[48\].rest.u_e.a VPWR VGND sg13cmos5l_a21o_1
Xx1.x11._084_ x1.cob0\[6\] net19 x1.x11.g_en\[48\].rest.u_e.a  x1.x11.g_en\[49\].rest.u_e.a VPWR VGND sg13cmos5l_a21o_1
Xx1.x11._085_ x1.co2\[0\] net22 x1.x11.g_en\[3\].rest.u_e.a  x1.x11.g_en\[4\].rest.u_e.a VPWR VGND sg13cmos5l_a21o_1
Xx1.x11._086_ x1.co1\[6\] net22 x1.x11.g_en\[49\].rest.u_e.a  x1.x11.g_en\[50\].rest.u_e.a VPWR VGND sg13cmos5l_a21o_1
Xx1.x11._087_ x1.cob1\[6\] net16 x1.x11.g_en\[50\].rest.u_e.a  x1.x11.g_en\[51\].rest.u_e.a VPWR VGND sg13cmos5l_a21o_1
Xx1.x11._088_ x1.co2\[6\] net15 x1.x11.g_en\[51\].rest.u_e.a  x1.x11.g_en\[52\].rest.u_e.a VPWR VGND sg13cmos5l_a21o_1
Xx1.x11._089_ x1.cob2\[6\] net15 x1.x11.g_en\[52\].rest.u_e.a  x1.x11.g_en\[53\].rest.u_e.a VPWR VGND sg13cmos5l_a21o_1
Xx1.x11._090_ x1.co3\[6\] net15 x1.x11.g_en\[53\].rest.u_e.a  x1.x11.g_en\[54\].rest.u_e.a VPWR VGND sg13cmos5l_a21o_1
Xx1.x11._091_ x1.cob3\[6\] net13 x1.x11.g_en\[54\].rest.u_e.a  x1.x11.g_en\[55\].rest.u_e.a VPWR VGND sg13cmos5l_a21o_1
Xx1.x11._092_ x1.co0\[7\] net17 x1.x11.g_en\[55\].rest.u_e.a  x1.x11.g_en\[56\].rest.u_e.a VPWR VGND sg13cmos5l_a21o_1
Xx1.x11._093_ x1.cob0\[7\] net20 x1.x11.g_en\[56\].rest.u_e.a  x1.x11.g_en\[57\].rest.u_e.a VPWR VGND sg13cmos5l_a21o_1
Xx1.x11._094_ x1.co1\[7\] net21 x1.x11.g_en\[57\].rest.u_e.a  x1.x11.g_en\[58\].rest.u_e.a VPWR VGND sg13cmos5l_a21o_1
Xx1.x11._095_ x1.cob1\[7\] net23 x1.x11.g_en\[58\].rest.u_e.a  x1.x11.g_en\[59\].rest.u_e.a VPWR VGND sg13cmos5l_a21o_1
Xx1.x11._096_ x1.cob2\[0\] net22 x1.x11.g_en\[4\].rest.u_e.a  x1.x11.g_en\[5\].rest.u_e.a VPWR VGND sg13cmos5l_a21o_1
Xx1.x11._097_ x1.co2\[7\] net22 x1.x11.g_en\[59\].rest.u_e.a  x1.x11.g_en\[60\].rest.u_e.a VPWR VGND sg13cmos5l_a21o_1
Xx1.x11._098_ x1.cob2\[7\] net16 x1.x11.g_en\[60\].rest.u_e.a  x1.x11.g_en\[61\].rest.u_e.a VPWR VGND sg13cmos5l_a21o_1
Xx1.x11._099_ x1.co3\[7\] net16 x1.x11.g_en\[61\].rest.u_e.a  x1.x11.g_en\[62\].rest.u_e.a VPWR VGND sg13cmos5l_a21o_1
Xx1.x11._100_ x1.co3\[0\] net19 x1.x11.g_en\[5\].rest.u_e.a  x1.x11.g_en\[6\].rest.u_e.a VPWR VGND sg13cmos5l_a21o_1
Xx1.x11._101_ x1.cob3\[0\] net19 x1.x11.g_en\[6\].rest.u_e.a  x1.x11.g_en\[7\].rest.u_e.a VPWR VGND sg13cmos5l_a21o_1
Xx1.x11._102_ x1.co0\[1\] net18 x1.x11.g_en\[7\].rest.u_e.a  x1.x11.g_en\[8\].rest.u_e.a VPWR VGND sg13cmos5l_a21o_1
Xx1.x11._103_ x1.cob0\[1\] net18 x1.x11.g_en\[8\].rest.u_e.a  x1.x11.g_en\[10\].rest.u_e.c VPWR VGND sg13cmos5l_a21o_1
Xx1.x11._104_ x1.x11.frac_on net x1.x11.n3 x11.g1 x1.x11.n1  net4 net5 VPWR VGND sg13cmos5l_mux4_1
Xx1.x11._105_ x1.x11.n1 x11.g1 x11.g0 VPWR VGND sg13cmos5l_or2_1
Xx1.x11._106_ x1.x11.n3 x11.g0 x11.g1 VPWR VGND sg13cmos5l_nor2b_1
Xx1.x11._107_ x1.x11._017_ net33 VPWR VGND sg13cmos5l_inv_1
Xx1.x11._108_ x1.x11._018_ net34 VPWR VGND sg13cmos5l_inv_1
Xx1.x11._109_ x1.x11._019_ net37 VPWR VGND sg13cmos5l_inv_1
Xx1.x11._110_ x1.x11._020_ net7 VPWR VGND sg13cmos5l_inv_1
Xx1.x11._111_ x1.x11._021_ net31 VPWR VGND sg13cmos5l_inv_1
Xx1.x11._112_ x1.x11._022_ net33 net31 VPWR VGND sg13cmos5l_nand2_1
Xx1.x11._113_ x1.x11.g_en\[47\].rest.u_e.a net27 VPWR VGND  sg13cmos5l_inv_1
Xx1.x11._114_ x1.x11._023_ net33 net34 VPWR VGND sg13cmos5l_nand2_1
Xx1.x11._115_ x1.x11._024_ net36 x1.x11.g_en\[47\].rest.u_e.a  VPWR VGND sg13cmos5l_nand2_1
Xx1.x11._116_ x1.x11.g_en\[55\].rest.u_e.a x1.x11._024_ VPWR  VGND sg13cmos5l_inv_1
Xx1.x11._117_ x1.x11._025_ net34 net37 VPWR VGND sg13cmos5l_and2_1
Xx1.x11._118_ x1.x11._026_ net35 net37 VPWR VGND sg13cmos5l_nand2_1
Xx1.x11._119_ x1.x11.g_en\[59\].rest.u_e.a net26 x1.x11._026_  VPWR VGND sg13cmos5l_nor2_1
Xx1.x11._120_ x1.x11._027_ net37 net7 VPWR VGND sg13cmos5l_nand2_1
Xx1.x11._121_ x1.x11.g_en\[61\].rest.u_e.a x1.x11._024_ x1.x11._027_  VPWR VGND sg13cmos5l_nor2_1
Xx1.x11._122_ x1.x11._028_ net7 net6 VPWR VGND sg13cmos5l_and2_1
Xx1.x11._123_ x1.x11._029_ net7 net6 VPWR VGND sg13cmos5l_nand2_1
Xx1.x11._124_ x1.x11.g_en\[62\].rest.u_e.a net26 x1.x11._026_  x1.x11._029_ VPWR VGND sg13cmos5l_nor3_1
Xx1.x11._125_ x1.x11._030_ net7 net6 VPWR VGND sg13cmos5l_or2_1
Xx1.x11._126_ x1.x11._031_ net34 x1.x11._030_ VPWR VGND sg13cmos5l_nand2_1
Xx1.x11._127_ x1.x11._032_ x1.x11._025_ x1.x11._030_ VPWR  VGND sg13cmos5l_nand2_1
Xx1.x11._128_ x1.x11.g_en\[60\].rest.u_e.a net27 x1.x11._032_  VPWR VGND sg13cmos5l_nor2_1
Xx1.x11._129_ x1.x11._033_ net7 net6 net37 VPWR VGND sg13cmos5l_a21oi_1
Xx1.x11._130_ x1.x11._034_ x1.x11._033_ net34 VPWR VGND sg13cmos5l_nand2b_1
Xx1.x11._131_ x1.x11.g_en\[58\].rest.u_e.a net27 x1.x11._034_  VPWR VGND sg13cmos5l_nor2_1
Xx1.x11._132_ x1.x11._035_ net37 net7 VPWR VGND sg13cmos5l_nor2_1
Xx1.x11._133_ x1.x11._036_ net37 net7 net34 VPWR VGND sg13cmos5l_o21ai_1
Xx1.x11._134_ x1.x11.g_en\[57\].rest.u_e.a net27 x1.x11._036_  VPWR VGND sg13cmos5l_nor2_1
Xx1.x11._135_ x1.x11._037_ net37 x1.x11._030_ net35 VPWR VGND  sg13cmos5l_o21ai_1
Xx1.x11._136_ x1.x11.g_en\[56\].rest.u_e.a net27 x1.x11._037_  VPWR VGND sg13cmos5l_nor2_1
Xx1.x11._137_ x1.x11._038_ net35 net8 VPWR VGND sg13cmos5l_nor2_1
Xx1.x11._138_ x1.x11._001_ net36 net8 VPWR VGND sg13cmos5l_or2_1
Xx1.x11._139_ x1.x11._002_ net31 x1.x11._001_ VPWR VGND sg13cmos5l_nand2_1
Xx1.x11._140_ x1.x11.g_en\[51\].rest.u_e.a net26 x1.x11._038_  VPWR VGND sg13cmos5l_nor2_1
Xx1.x11._141_ x1.x11._003_ net36 x1.x11._028_ VPWR VGND sg13cmos5l_nor2_1
Xx1.x11._142_ x1.x11.g_en\[54\].rest.u_e.a x1.x11._003_ x1.x11.g_en\[51\].rest.u_e.a  VPWR VGND sg13cmos5l_nor2b_1
Xx1.x11._143_ x1.x11.g_en\[53\].rest.u_e.a x1.x11._018_ x1.x11._027_  net27 VPWR VGND sg13cmos5l_a21oi_1
Xx1.x11._144_ x1.x11._004_ net36 x1.x11._030_ VPWR VGND sg13cmos5l_nor2_1
Xx1.x11._145_ x1.x11.g_en\[52\].rest.u_e.a x1.x11._004_ x1.x11.g_en\[51\].rest.u_e.a  VPWR VGND sg13cmos5l_nor2b_1
Xx1.x11._146_ x1.x11.g_en\[49\].rest.u_e.a x1.x11._020_ x1.x11._038_  net26 VPWR VGND sg13cmos5l_a21oi_1
Xx1.x11._147_ x1.x11.g_en\[50\].rest.u_e.a x1.x11._029_ x1.x11._038_  net26 VPWR VGND sg13cmos5l_a21oi_1
Xx1.x11._148_ x1.x11._005_ x1.x11._030_ x1.x11._001_ VPWR  VGND sg13cmos5l_nor2_1
Xx1.x11._149_ x1.x11.g_en\[48\].rest.u_e.a net27 x1.x11._005_  VPWR VGND sg13cmos5l_nor2_1
Xx1.x11._150_ x1.x11._006_ net33 x1.x11._025_ net31 VPWR VGND  sg13cmos5l_o21ai_1
Xx1.x11._151_ x1.x11.g_en\[43\].rest.u_e.a x1.x11._006_ VPWR  VGND sg13cmos5l_inv_1
Xx1.x11._152_ x1.x11._007_ x1.x11._025_ x1.x11._028_ net33  VPWR VGND sg13cmos5l_a21oi_1
Xx1.x11._153_ x1.x11.g_en\[46\].rest.u_e.a net29 x1.x11._007_  VPWR VGND sg13cmos5l_nor2_1
Xx1.x11._154_ x1.x11._008_ net10 net34 VPWR VGND sg13cmos5l_nor2_1
Xx1.x11._155_ x1.x11.g_en\[39\].rest.u_e.a net28 x1.x11._008_  VPWR VGND sg13cmos5l_nor2_1
Xx1.x11._156_ x1.x11.g_en\[45\].rest.u_e.a net30 x1.x11._020_  x1.x11._006_ VPWR VGND sg13cmos5l_a21oi_1
Xx1.x11._157_ x1.x11.g_en\[44\].rest.u_e.a net30 x1.x11._032_  net28 VPWR VGND sg13cmos5l_a21oi_1
Xx1.x11._158_ x1.x11.g_en\[42\].rest.u_e.a net30 x1.x11._034_  net28 VPWR VGND sg13cmos5l_a21oi_1
Xx1.x11._159_ x1.x11.g_en\[41\].rest.u_e.a net30 x1.x11._036_  net28 VPWR VGND sg13cmos5l_a21oi_1
Xx1.x11._160_ x1.x11.g_en\[40\].rest.u_e.a net30 x1.x11._037_  net28 VPWR VGND sg13cmos5l_a21oi_1
Xx1.x11._161_ x1.x11.g_en\[35\].rest.u_e.a net26 x1.x11._002_  VPWR VGND sg13cmos5l_nand2_1
Xx1.x11._162_ x1.x11.g_en\[38\].rest.u_e.a x1.x11._002_ x1.x11._003_  net26 VPWR VGND sg13cmos5l_o21ai_1
Xx1.x11._163_ x1.x11.g_en\[37\].rest.u_e.a x1.x11._027_ x1.x11._008_  net29 VPWR VGND sg13cmos5l_a21oi_1
Xx1.x11._164_ x1.x11.g_en\[36\].rest.u_e.a x1.x11._002_ x1.x11._004_  net26 VPWR VGND sg13cmos5l_o21ai_1
Xx1.x11._165_ x1.x11.g_en\[34\].rest.u_e.a x1.x11._033_ x1.x11._008_  x1.x11._021_ VPWR VGND sg13cmos5l_a21oi_1
Xx1.x11._166_ x1.x11.g_en\[33\].rest.u_e.a x1.x11._035_ x1.x11._008_  net28 VPWR VGND sg13cmos5l_a21oi_1
Xx1.x11._167_ x1.x11.g_en\[32\].rest.u_e.a x1.x11._017_ x1.x11._005_  net28 VPWR VGND sg13cmos5l_a21oi_1
Xx1.x11._168_ x1.x11._009_ net10 net31 VPWR VGND sg13cmos5l_nor2_1
Xx1.x11._169_ x1.x11.g_en\[15\].rest.u_e.a net24 VPWR VGND  sg13cmos5l_inv_1
Xx1.x11._170_ x1.x11._010_ net31 x1.x11._025_ VPWR VGND sg13cmos5l_nor2_1
Xx1.x11._171_ x1.x11._011_ net33 x1.x11._025_ net32 VPWR VGND  sg13cmos5l_a21oi_1
Xx1.x11._172_ x1.x11.g_en\[27\].rest.u_e.a x1.x11._011_ VPWR  VGND sg13cmos5l_inv_1
Xx1.x11._173_ x1.x11._012_ net32 x1.x11._028_ VPWR VGND sg13cmos5l_nor2_1
Xx1.x11._174_ x1.x11.g_en\[30\].rest.u_e.a x1.x11._011_ x1.x11._012_  VPWR VGND sg13cmos5l_nor2_1
Xx1.x11._175_ x1.x11._013_ net33 net36 net32 VPWR VGND sg13cmos5l_a21oi_1
Xx1.x11._176_ x1.x11.g_en\[23\].rest.u_e.a x1.x11._013_ VPWR  VGND sg13cmos5l_inv_1
Xx1.x11._177_ x1.x11.g_en\[29\].rest.u_e.a x1.x11._023_ x1.x11._027_  net29 VPWR VGND sg13cmos5l_o21ai_1
Xx1.x11._178_ x1.x11._014_ net32 x1.x11._030_ VPWR VGND sg13cmos5l_nor2_1
Xx1.x11._179_ x1.x11.g_en\[28\].rest.u_e.a x1.x11._011_ x1.x11._014_  VPWR VGND sg13cmos5l_nor2_1
Xx1.x11._180_ x1.x11.g_en\[26\].rest.u_e.a x1.x11._019_ x1.x11._012_  x1.x11._013_ VPWR VGND sg13cmos5l_a21oi_1
Xx1.x11._181_ x1.x11.g_en\[25\].rest.u_e.a x1.x11._023_ x1.x11._035_  net29 VPWR VGND sg13cmos5l_o21ai_1
Xx1.x11._182_ x1.x11.g_en\[24\].rest.u_e.a x1.x11._031_ x1.x11._010_  net24 VPWR VGND sg13cmos5l_a21oi_1
Xx1.x11._183_ x1.x11._015_ net33 x1.x11._001_ net31 VPWR VGND  sg13cmos5l_a21oi_1
Xx1.x11._184_ x1.x11.g_en\[19\].rest.u_e.a x1.x11._015_ VPWR  VGND sg13cmos5l_inv_1
Xx1.x11._185_ x1.x11.g_en\[22\].rest.u_e.a net29 x1.x11._003_  x1.x11._015_ VPWR VGND sg13cmos5l_a21oi_1
Xx1.x11._186_ x1.x11.g_en\[21\].rest.u_e.a net30 x1.x11._027_  x1.x11._013_ VPWR VGND sg13cmos5l_o21ai_1
Xx1.x11._187_ x1.x11.g_en\[20\].rest.u_e.a net29 x1.x11._004_  x1.x11._015_ VPWR VGND sg13cmos5l_a21oi_1
Xx1.x11._188_ x1.x11.g_en\[18\].rest.u_e.a x1.x11._029_ net24  x1.x11._015_ VPWR VGND sg13cmos5l_o21ai_1
Xx1.x11._189_ x1.x11.g_en\[17\].rest.u_e.a net30 x1.x11._020_  x1.x11._015_ VPWR VGND sg13cmos5l_o21ai_1
Xx1.x11._190_ x1.x11.g_en\[16\].rest.u_e.a net30 x1.x11._005_  net28 VPWR VGND sg13cmos5l_o21ai_1
Xx1.x11._191_ x1.x11.g_en\[14\].rest.u_e.a net29 x1.x11._007_  VPWR VGND sg13cmos5l_nand2_1
Xx1.x11._192_ x1.x11._016_ net10 net34 net32 VPWR VGND sg13cmos5l_nor3_1
Xx1.x11._193_ x1.x11.g_en\[7\].rest.u_e.a x1.x11._016_ VPWR  VGND sg13cmos5l_inv_1
Xx1.x11._194_ x1.x11.g_en\[13\].rest.u_e.a x1.x11._020_ x1.x11._026_  net24 VPWR VGND sg13cmos5l_o21ai_1
Xx1.x11._195_ x1.x11.g_en\[12\].rest.u_e.a x1.x11._032_ net24  VPWR VGND sg13cmos5l_nand2_1
Xx1.x11._196_ x1.x11.g_en\[11\].rest.u_e.a x1.x11._026_ net25  VPWR VGND sg13cmos5l_nand2_1
Xx1.x11._197_ x1.x11.g_en\[10\].rest.u_e.a x1.x11._034_ net25  VPWR VGND sg13cmos5l_nand2_1
Xx1.x11._198_ x1.x11.g_en\[10\].rest.u_e.c x1.x11._018_ x1.x11._035_  net24 VPWR VGND sg13cmos5l_o21ai_1
Xx1.x11._199_ x1.x11.g_en\[8\].rest.u_e.a x1.x11._037_ net24  VPWR VGND sg13cmos5l_nand2_1
Xx1.x11._200_ x1.x11.g_en\[3\].rest.u_e.a x1.x11._038_ net25  VPWR VGND sg13cmos5l_nand2_1
Xx1.x11._201_ x1.x11.g_en\[6\].rest.u_e.a x1.x11._019_ x1.x11._029_  x1.x11._016_ VPWR VGND sg13cmos5l_o21ai_1
Xx1.x11._202_ x1.x11.g_en\[5\].rest.u_e.a x1.x11._027_ x1.x11._016_  VPWR VGND sg13cmos5l_nand2_1
Xx1.x11._203_ x1.x11.g_en\[4\].rest.u_e.a x1.x11._038_ x1.x11._004_  net25 VPWR VGND sg13cmos5l_o21ai_1
Xx1.x11._204_ x1.x11.g_en\[2\].rest.u_e.a x1.x11._033_ x1.x11._016_  VPWR VGND sg13cmos5l_nand2_1
Xx1.x11._205_ x1.x11.g_en\[1\].rest.u_e.a x1.x11._035_ x1.x11._016_  VPWR VGND sg13cmos5l_nand2_1
Xx1.x11._206_ x1.x11.g_en\[0\].first.u_e.a x1.x11._005_ net24  VPWR VGND sg13cmos5l_nand2_1
Xx1.x2 clk_outb x1.net10 VPWR VGND sg13cmos5l_inv_16
Xx1.x3.x11 x1.net6 x1.net5 VPWR VGND sg13cmos5l_inv_1
Xx1.x3.x12 x1.net5 x1.net6 VPWR VGND sg13cmos5l_inv_1
Xx1.x3.x13 x1.net6 x1.net7 VPWR VGND sg13cmos5l_inv_2
Xx1.x3.x14 x1.net5 x1.net8 VPWR VGND sg13cmos5l_inv_2
Xx1.x3.xco0 x1.co0\[0\] x1.net6 VPWR VGND custom_cap_8
Xx1.x3.xco1 x1.co0\[1\] x1.net6 VPWR VGND custom_cap_8
Xx1.x3.xco2 x1.co0\[2\] x1.net6 VPWR VGND custom_cap_8
Xx1.x3.xco3 x1.co0\[3\] x1.net6 VPWR VGND custom_cap_8
Xx1.x3.xco4 x1.co0\[4\] x1.net6 VPWR VGND custom_cap_8
Xx1.x3.xco5 x1.co0\[5\] x1.net6 VPWR VGND custom_cap_8
Xx1.x3.xco6 x1.co0\[6\] x1.net6 VPWR VGND custom_cap_8
Xx1.x3.xco7 x1.co0\[7\] x1.net6 VPWR VGND custom_cap_8
Xx1.x3.xcob0 x1.cob0\[0\] x1.net5 VPWR VGND custom_cap_8
Xx1.x3.xcob1 x1.cob0\[1\] x1.net5 VPWR VGND custom_cap_8
Xx1.x3.xcob2 x1.cob0\[2\] x1.net5 VPWR VGND custom_cap_8
Xx1.x3.xcob3 x1.cob0\[3\] x1.net5 VPWR VGND custom_cap_8
Xx1.x3.xcob4 x1.cob0\[4\] x1.net5 VPWR VGND custom_cap_8
Xx1.x3.xcob5 x1.cob0\[5\] x1.net5 VPWR VGND custom_cap_8
Xx1.x3.xcob6 x1.cob0\[6\] x1.net5 VPWR VGND custom_cap_8
Xx1.x3.xcob7 x1.cob0\[7\] x1.net5 VPWR VGND custom_cap_8
Xx1.x4.x11 x1.net4 x1.net1 VPWR VGND sg13cmos5l_inv_1
Xx1.x4.x12 x1.net1 x1.net4 VPWR VGND sg13cmos5l_inv_1
Xx1.x4.x13 x1.net4 x1.net6 VPWR VGND sg13cmos5l_inv_2
Xx1.x4.x14 x1.net1 x1.net5 VPWR VGND sg13cmos5l_inv_2
Xx1.x4.xco0 x1.co1\[0\] x1.net4 VPWR VGND custom_cap_8
Xx1.x4.xco1 x1.co1\[1\] x1.net4 VPWR VGND custom_cap_8
Xx1.x4.xco2 x1.co1\[2\] x1.net4 VPWR VGND custom_cap_8
Xx1.x4.xco3 x1.co1\[3\] x1.net4 VPWR VGND custom_cap_8
Xx1.x4.xco4 x1.co1\[4\] x1.net4 VPWR VGND custom_cap_8
Xx1.x4.xco5 x1.co1\[5\] x1.net4 VPWR VGND custom_cap_8
Xx1.x4.xco6 x1.co1\[6\] x1.net4 VPWR VGND custom_cap_8
Xx1.x4.xco7 x1.co1\[7\] x1.net4 VPWR VGND custom_cap_8
Xx1.x4.xcob0 x1.cob1\[0\] x1.net1 VPWR VGND custom_cap_8
Xx1.x4.xcob1 x1.cob1\[1\] x1.net1 VPWR VGND custom_cap_8
Xx1.x4.xcob2 x1.cob1\[2\] x1.net1 VPWR VGND custom_cap_8
Xx1.x4.xcob3 x1.cob1\[3\] x1.net1 VPWR VGND custom_cap_8
Xx1.x4.xcob4 x1.cob1\[4\] x1.net1 VPWR VGND custom_cap_8
Xx1.x4.xcob5 x1.cob1\[5\] x1.net1 VPWR VGND custom_cap_8
Xx1.x4.xcob6 x1.cob1\[6\] x1.net1 VPWR VGND custom_cap_8
Xx1.x4.xcob7 x1.cob1\[7\] x1.net1 VPWR VGND custom_cap_8
Xx1.x5.x11 x1.net2 x1.net3 VPWR VGND sg13cmos5l_inv_1
Xx1.x5.x12 x1.net3 x1.net2 VPWR VGND sg13cmos5l_inv_1
Xx1.x5.x13 x1.net2 x1.net4 VPWR VGND sg13cmos5l_inv_2
Xx1.x5.x14 x1.net3 x1.net1 VPWR VGND sg13cmos5l_inv_2
Xx1.x5.xco0 x1.co2\[0\] x1.net2 VPWR VGND custom_cap_8
Xx1.x5.xco1 x1.co2\[1\] x1.net2 VPWR VGND custom_cap_8
Xx1.x5.xco2 x1.co2\[2\] x1.net2 VPWR VGND custom_cap_8
Xx1.x5.xco3 x1.co2\[3\] x1.net2 VPWR VGND custom_cap_8
Xx1.x5.xco4 x1.co2\[4\] x1.net2 VPWR VGND custom_cap_8
Xx1.x5.xco5 x1.co2\[5\] x1.net2 VPWR VGND custom_cap_8
Xx1.x5.xco6 x1.co2\[6\] x1.net2 VPWR VGND custom_cap_8
Xx1.x5.xco7 x1.co2\[7\] x1.net2 VPWR VGND custom_cap_8
Xx1.x5.xcob0 x1.cob2\[0\] x1.net3 VPWR VGND custom_cap_8
Xx1.x5.xcob1 x1.cob2\[1\] x1.net3 VPWR VGND custom_cap_8
Xx1.x5.xcob2 x1.cob2\[2\] x1.net3 VPWR VGND custom_cap_8
Xx1.x5.xcob3 x1.cob2\[3\] x1.net3 VPWR VGND custom_cap_8
Xx1.x5.xcob4 x1.cob2\[4\] x1.net3 VPWR VGND custom_cap_8
Xx1.x5.xcob5 x1.cob2\[5\] x1.net3 VPWR VGND custom_cap_8
Xx1.x5.xcob6 x1.cob2\[6\] x1.net3 VPWR VGND custom_cap_8
Xx1.x5.xcob7 x1.cob2\[7\] x1.net3 VPWR VGND custom_cap_8
Xx1.x6.x11 x1.ring_p x1.ring_n VPWR VGND sg13cmos5l_inv_1
Xx1.x6.x12 x1.ring_n x1.ring_p VPWR VGND sg13cmos5l_inv_1
Xx1.x6.x13 x1.ring_p x1.net2 VPWR VGND sg13cmos5l_inv_2
Xx1.x6.x14 x1.ring_n x1.net3 VPWR VGND sg13cmos5l_inv_2
Xx1.x6.xco0 x1.co3\[0\] x1.ring_p VPWR VGND custom_cap_8
Xx1.x6.xco1 x1.co3\[1\] x1.ring_p VPWR VGND custom_cap_8
Xx1.x6.xco2 x1.co3\[2\] x1.ring_p VPWR VGND custom_cap_8
Xx1.x6.xco3 x1.co3\[3\] x1.ring_p VPWR VGND custom_cap_8
Xx1.x6.xco4 x1.co3\[4\] x1.ring_p VPWR VGND custom_cap_8
Xx1.x6.xco5 x1.co3\[5\] x1.ring_p VPWR VGND custom_cap_8
Xx1.x6.xco6 x1.co3\[6\] x1.ring_p VPWR VGND custom_cap_8
Xx1.x6.xco7 x1.co3\[7\] x1.ring_p VPWR VGND custom_cap_8
Xx1.x6.xcob0 x1.cob3\[0\] x1.ring_n VPWR VGND custom_cap_8
Xx1.x6.xcob1 x1.cob3\[1\] x1.ring_n VPWR VGND custom_cap_8
Xx1.x6.xcob2 x1.cob3\[2\] x1.ring_n VPWR VGND custom_cap_8
Xx1.x6.xcob3 x1.cob3\[3\] x1.ring_n VPWR VGND custom_cap_8
Xx1.x6.xcob4 x1.cob3\[4\] x1.ring_n VPWR VGND custom_cap_8
Xx1.x6.xcob5 x1.cob3\[5\] x1.ring_n VPWR VGND custom_cap_8
Xx1.x6.xcob6 x1.cob3\[6\] x1.ring_n VPWR VGND custom_cap_8
Xx1.x6.xcob7 net38 x1.ring_n VPWR VGND custom_cap_8
Xx1.x7 x1.net7 M_outb VPWR VGND sg13cmos5l_inv_2
Xx1.x8 x1.net8 M_out VPWR VGND sg13cmos5l_inv_2
Xx1.x9 M_outb x1.ring_p clk_ref sel_i VPWR VGND sg13cmos5l_mux2_2
Xx1.xb1 x1.net9 x1.ring_p VPWR VGND sg13cmos5l_inv_1
Xx1.xb2 x1.net10 x1.net9 VPWR VGND sg13cmos5l_inv_4
Xx1.xb3 x1.net11 x1.ring_n VPWR VGND sg13cmos5l_inv_1
Xx1.xb4 x1.net12 x1.net11 VPWR VGND sg13cmos5l_inv_4
Xx11.x6_40 net42 VPWR VGND sg13cmos5l_tiehi
Xx11.x1 x11.g0 x11.net2 ring_out net44 div_rstb_c VPWR VGND  sg13cmos5l_dfrbp_1
Xx11.x2 x11.g1 x11.g1b ring_out x11.g0 div_rstb_c VPWR VGND  sg13cmos5l_dfrbp_1
Xx11.x4 divn1 x11.g0 x11.g1 VPWR VGND sg13cmos5l_nor2b_1
Xx11.x5 x11.net1 ring_out x11.gate VPWR VGND sg13cmos5l_lgcp_1
Xx11.x6 x11.gate divn1 net42 x11.arm_rstb VPWR VGND sg13cmos5l_dfrbpq_1
Xx11.x7 x11.arm_rstb div net12 VPWR VGND sg13cmos5l_nor2b_1
Xx4.x1_41 net43 VPWR VGND sg13cmos5l_tiehi
Xx11.x9 div x11.net1 VPWR VGND sg13cmos5l_buf_4
Xx12 div_rstb_s net3 clk_outb net40 div_rstb VPWR VGND sg13cmos5l_dfrbp_1
Xx13 div_rstb_c div_rstb_s selb net12 VPWR VGND sg13cmos5l_and3_2
Xx14 clk_out ring_out VPWR VGND sg13cmos5l_buf_1
Xx15 sel sel_i VPWR VGND sg13cmos5l_buf_1
Xx4.x1 x4.net3 x4.net5 divn1 net43 x4.net1 VPWR VGND sg13cmos5l_dfrbp_1
Xx4.x2 x4.net1 net39 x4.net2 net12 VPWR VGND sg13cmos5l_mux2_1
Xx4.x3 x4.net2 sel_i M_outb VPWR VGND sg13cmos5l_nand2_1
Xx4.x4 x4.net4 x4.net3 M_out_g VPWR VGND sg13cmos5l_nand2_1
Xx4.x5 sel_i x4.net4 net12 VPWR VGND sg13cmos5l_nand2_1
Xx4.x6 selb sel_i VPWR VGND sg13cmos5l_inv_2
Xhold42 net44 x11.g1b VPWR VGND sg13cmos5l_dlygate4sd3_1
Xx12_38 net40 VPWR VGND sg13cmos5l_tiehi
Xx5 clk_refb clk_ref VPWR VGND sg13cmos5l_inv_1
Xx6 div_rstb net12 selb VPWR VGND sg13cmos5l_and2_2
Xx7 ref_fell net1 clk_refb net41 div_rstb VPWR VGND sg13cmos5l_dfrbp_1
Xx8 armed net2 M_outb ref_fell net12 VPWR VGND sg13cmos5l_dfrbp_1
Xx9 M_out_g M_out armed VPWR VGND sg13cmos5l_and2_1
Xinput1 net4 C[0] VPWR VGND sg13cmos5l_buf_1
Xinput2 net5 C[1] VPWR VGND sg13cmos5l_buf_1
Xinput3 net6 C[2] VPWR VGND sg13cmos5l_buf_1
Xinput4 net7 C[3] VPWR VGND sg13cmos5l_buf_1
Xinput5 net8 C[4] VPWR VGND sg13cmos5l_buf_1
Xinput6 net9 C[5] VPWR VGND sg13cmos5l_buf_1
Xinput7 net10 C[6] VPWR VGND sg13cmos5l_buf_1
Xinput8 net11 C[7] VPWR VGND sg13cmos5l_buf_1
Xinput9 net12 Resetb VPWR VGND sg13cmos5l_buf_1
Xfanout10 net13 net17 VPWR VGND sg13cmos5l_buf_1
Xfanout11 net14 net15 VPWR VGND sg13cmos5l_buf_1
Xfanout12 net15 net17 VPWR VGND sg13cmos5l_buf_1
Xfanout13 net16 net17 VPWR VGND sg13cmos5l_buf_1
Xfanout14 net17 x1.x11.frac_on VPWR VGND sg13cmos5l_buf_1
Xfanout15 net18 net20 VPWR VGND sg13cmos5l_buf_1
Xfanout16 net19 net23 VPWR VGND sg13cmos5l_buf_1
Xfanout17 net20 net23 VPWR VGND sg13cmos5l_buf_1
Xfanout18 net21 net22 VPWR VGND sg13cmos5l_buf_1
Xfanout19 net22 net23 VPWR VGND sg13cmos5l_buf_1
Xfanout20 net23 x1.x11.frac_on VPWR VGND sg13cmos5l_buf_1
Xfanout21 net24 x1.x11._009_ VPWR VGND sg13cmos5l_buf_1
Xfanout22 net25 x1.x11._009_ VPWR VGND sg13cmos5l_buf_1
Xfanout23 net26 net27 VPWR VGND sg13cmos5l_buf_1
Xfanout24 net27 x1.x11._022_ VPWR VGND sg13cmos5l_buf_1
Xfanout25 net28 net29 VPWR VGND sg13cmos5l_buf_1
Xfanout26 net29 x1.x11._021_ VPWR VGND sg13cmos5l_buf_1
Xfanout27 net30 x1.x11._017_ VPWR VGND sg13cmos5l_buf_1
Xfanout28 net31 net32 VPWR VGND sg13cmos5l_buf_1
Xfanout29 net32 net11 VPWR VGND sg13cmos5l_buf_1
Xfanout30 net33 net10 VPWR VGND sg13cmos5l_buf_1
Xfanout31 net34 net35 VPWR VGND sg13cmos5l_buf_1
Xfanout32 net35 net36 VPWR VGND sg13cmos5l_buf_1
Xfanout33 net36 net9 VPWR VGND sg13cmos5l_buf_1
Xfanout34 net37 net8 VPWR VGND sg13cmos5l_buf_1
Xx1.x11._104__35 net VPWR VGND sg13cmos5l_tielo
Xx7_39 net41 VPWR VGND sg13cmos5l_tiehi
XFILLER_0_6 VPWR VGND sg13cmos5l_decap_8
XFILLER_0_13 VPWR VGND sg13cmos5l_decap_4
XFILLER_0_50 VPWR VGND sg13cmos5l_decap_8
XFILLER_0_57 VPWR VGND sg13cmos5l_decap_4
XFILLER_0_90 VPWR VGND sg13cmos5l_decap_8
XFILLER_0_97 VPWR VGND sg13cmos5l_decap_8
XFILLER_0_117 VPWR VGND sg13cmos5l_decap_4
XFILLER_0_127 VPWR VGND sg13cmos5l_decap_8
XFILLER_0_134 VPWR VGND sg13cmos5l_decap_8
XFILLER_0_147 VPWR VGND sg13cmos5l_decap_4
XFILLER_0_157 VPWR VGND sg13cmos5l_decap_4
XFILLER_0_175 VPWR VGND sg13cmos5l_decap_8
XFILLER_0_182 VPWR VGND sg13cmos5l_decap_4
XFILLER_1_9 VPWR VGND sg13cmos5l_decap_8
XFILLER_1_50 VPWR VGND sg13cmos5l_decap_8
XFILLER_1_92 VPWR VGND sg13cmos5l_decap_8
XFILLER_1_134 VPWR VGND sg13cmos5l_decap_8
XFILLER_1_141 VPWR VGND sg13cmos5l_decap_4
XFILLER_1_175 VPWR VGND sg13cmos5l_decap_8
XFILLER_1_182 VPWR VGND sg13cmos5l_decap_4
XFILLER_2_9 VPWR VGND sg13cmos5l_decap_8
XFILLER_2_50 VPWR VGND sg13cmos5l_decap_8
XFILLER_2_79 VPWR VGND sg13cmos5l_decap_8
XFILLER_2_92 VPWR VGND sg13cmos5l_decap_8
XFILLER_2_115 VPWR VGND sg13cmos5l_decap_4
XFILLER_2_130 VPWR VGND sg13cmos5l_decap_8
XFILLER_2_137 VPWR VGND sg13cmos5l_decap_4
XFILLER_2_175 VPWR VGND sg13cmos5l_decap_8
XFILLER_2_182 VPWR VGND sg13cmos5l_decap_4
XFILLER_3_0 VPWR VGND sg13cmos5l_decap_8
XFILLER_3_7 VPWR VGND sg13cmos5l_decap_8
XFILLER_3_45 VPWR VGND sg13cmos5l_decap_8
XFILLER_3_52 VPWR VGND sg13cmos5l_decap_8
XFILLER_3_92 VPWR VGND sg13cmos5l_decap_8
XFILLER_3_114 VPWR VGND sg13cmos5l_decap_8
XFILLER_3_134 VPWR VGND sg13cmos5l_decap_8
XFILLER_3_141 VPWR VGND sg13cmos5l_decap_8
XFILLER_3_175 VPWR VGND sg13cmos5l_decap_8
XFILLER_3_182 VPWR VGND sg13cmos5l_decap_4
XFILLER_4_9 VPWR VGND sg13cmos5l_decap_8
XFILLER_4_50 VPWR VGND sg13cmos5l_decap_8
XFILLER_4_63 VPWR VGND sg13cmos5l_decap_8
XFILLER_4_92 VPWR VGND sg13cmos5l_decap_8
XFILLER_4_134 VPWR VGND sg13cmos5l_decap_8
XFILLER_4_175 VPWR VGND sg13cmos5l_decap_8
XFILLER_4_182 VPWR VGND sg13cmos5l_decap_4
XFILLER_5_0 VPWR VGND sg13cmos5l_decap_8
XFILLER_5_7 VPWR VGND sg13cmos5l_decap_8
XFILLER_5_14 VPWR VGND sg13cmos5l_decap_8
XFILLER_5_50 VPWR VGND sg13cmos5l_decap_8
XFILLER_5_76 VPWR VGND sg13cmos5l_decap_4
XFILLER_5_92 VPWR VGND sg13cmos5l_decap_8
XFILLER_5_134 VPWR VGND sg13cmos5l_decap_8
XFILLER_5_150 VPWR VGND sg13cmos5l_decap_4
XFILLER_5_175 VPWR VGND sg13cmos5l_decap_8
XFILLER_5_182 VPWR VGND sg13cmos5l_decap_4
XFILLER_6_0 VPWR VGND sg13cmos5l_decap_4
XFILLER_6_9 VPWR VGND sg13cmos5l_decap_8
XFILLER_6_43 VPWR VGND sg13cmos5l_decap_8
XFILLER_6_50 VPWR VGND sg13cmos5l_decap_8
XFILLER_6_71 VPWR VGND sg13cmos5l_decap_4
XFILLER_6_83 VPWR VGND sg13cmos5l_decap_8
XFILLER_6_90 VPWR VGND sg13cmos5l_decap_8
XFILLER_6_107 VPWR VGND sg13cmos5l_decap_8
XFILLER_6_128 VPWR VGND sg13cmos5l_decap_8
XFILLER_6_135 VPWR VGND sg13cmos5l_decap_8
XFILLER_6_153 VPWR VGND sg13cmos5l_decap_8
XFILLER_6_173 VPWR VGND sg13cmos5l_decap_8
XFILLER_6_180 VPWR VGND sg13cmos5l_decap_4
XFILLER_7_0 VPWR VGND sg13cmos5l_decap_4
XFILLER_7_8 VPWR VGND sg13cmos5l_decap_8
XFILLER_7_44 VPWR VGND sg13cmos5l_decap_8
XFILLER_7_51 VPWR VGND sg13cmos5l_decap_8
XFILLER_7_92 VPWR VGND sg13cmos5l_decap_8
XFILLER_7_132 VPWR VGND sg13cmos5l_decap_8
XFILLER_7_175 VPWR VGND sg13cmos5l_decap_8
XFILLER_7_182 VPWR VGND sg13cmos5l_decap_4
XFILLER_8_0 VPWR VGND sg13cmos5l_decap_4
XFILLER_8_9 VPWR VGND sg13cmos5l_decap_8
XFILLER_8_50 VPWR VGND sg13cmos5l_decap_8
XFILLER_8_66 VPWR VGND sg13cmos5l_decap_8
XFILLER_8_73 VPWR VGND sg13cmos5l_decap_4
XFILLER_8_80 VPWR VGND sg13cmos5l_decap_8
XFILLER_8_87 VPWR VGND sg13cmos5l_decap_8
XFILLER_8_94 VPWR VGND sg13cmos5l_decap_8
XFILLER_8_101 VPWR VGND sg13cmos5l_decap_8
XFILLER_8_108 VPWR VGND sg13cmos5l_decap_8
XFILLER_8_115 VPWR VGND sg13cmos5l_decap_8
XFILLER_8_122 VPWR VGND sg13cmos5l_decap_8
XFILLER_8_129 VPWR VGND sg13cmos5l_decap_8
XFILLER_8_136 VPWR VGND sg13cmos5l_decap_4
XFILLER_8_154 VPWR VGND sg13cmos5l_decap_4
XFILLER_8_175 VPWR VGND sg13cmos5l_decap_8
XFILLER_8_182 VPWR VGND sg13cmos5l_decap_4
XFILLER_9_9 VPWR VGND sg13cmos5l_decap_8
XFILLER_9_38 VPWR VGND sg13cmos5l_decap_8
XFILLER_9_45 VPWR VGND sg13cmos5l_decap_8
XFILLER_9_52 VPWR VGND sg13cmos5l_decap_8
XFILLER_9_88 VPWR VGND sg13cmos5l_decap_8
XFILLER_9_95 VPWR VGND sg13cmos5l_decap_8
XFILLER_9_112 VPWR VGND sg13cmos5l_decap_8
XFILLER_9_119 VPWR VGND sg13cmos5l_decap_4
XFILLER_9_133 VPWR VGND sg13cmos5l_decap_8
XFILLER_9_150 VPWR VGND sg13cmos5l_decap_8
XFILLER_9_175 VPWR VGND sg13cmos5l_decap_8
XFILLER_9_182 VPWR VGND sg13cmos5l_decap_4
XFILLER_10_0 VPWR VGND sg13cmos5l_decap_8
XFILLER_10_7 VPWR VGND sg13cmos5l_decap_8
XFILLER_10_50 VPWR VGND sg13cmos5l_decap_8
XFILLER_10_68 VPWR VGND sg13cmos5l_decap_8
XFILLER_10_75 VPWR VGND sg13cmos5l_decap_8
XFILLER_10_82 VPWR VGND sg13cmos5l_decap_4
XFILLER_10_92 VPWR VGND sg13cmos5l_decap_8
XFILLER_10_107 VPWR VGND sg13cmos5l_decap_8
XFILLER_10_114 VPWR VGND sg13cmos5l_decap_8
XFILLER_10_128 VPWR VGND sg13cmos5l_decap_8
XFILLER_10_135 VPWR VGND sg13cmos5l_decap_8
XFILLER_10_142 VPWR VGND sg13cmos5l_decap_4
XFILLER_10_155 VPWR VGND sg13cmos5l_decap_8
XFILLER_10_175 VPWR VGND sg13cmos5l_decap_8
XFILLER_10_182 VPWR VGND sg13cmos5l_decap_4
XFILLER_11_9 VPWR VGND sg13cmos5l_decap_8
XFILLER_11_42 VPWR VGND sg13cmos5l_decap_8
XFILLER_11_49 VPWR VGND sg13cmos5l_decap_8
XFILLER_11_71 VPWR VGND sg13cmos5l_decap_8
XFILLER_11_78 VPWR VGND sg13cmos5l_decap_8
XFILLER_11_85 VPWR VGND sg13cmos5l_decap_8
XFILLER_11_92 VPWR VGND sg13cmos5l_decap_8
XFILLER_11_99 VPWR VGND sg13cmos5l_decap_8
XFILLER_11_106 VPWR VGND sg13cmos5l_decap_8
XFILLER_11_113 VPWR VGND sg13cmos5l_decap_4
XFILLER_11_122 VPWR VGND sg13cmos5l_decap_4
XFILLER_11_130 VPWR VGND sg13cmos5l_decap_8
XFILLER_11_137 VPWR VGND sg13cmos5l_decap_4
XFILLER_11_156 VPWR VGND sg13cmos5l_decap_8
XFILLER_11_175 VPWR VGND sg13cmos5l_decap_8
XFILLER_11_182 VPWR VGND sg13cmos5l_decap_4
XFILLER_12_0 VPWR VGND sg13cmos5l_decap_8
XFILLER_12_7 VPWR VGND sg13cmos5l_decap_8
XFILLER_12_14 VPWR VGND sg13cmos5l_decap_4
XFILLER_12_27 VPWR VGND sg13cmos5l_decap_4
XFILLER_12_50 VPWR VGND sg13cmos5l_decap_8
XFILLER_12_64 VPWR VGND sg13cmos5l_decap_4
XFILLER_12_92 VPWR VGND sg13cmos5l_decap_8
XFILLER_12_112 VPWR VGND sg13cmos5l_decap_8
XFILLER_12_130 VPWR VGND sg13cmos5l_decap_8
XFILLER_12_137 VPWR VGND sg13cmos5l_decap_4
XFILLER_12_156 VPWR VGND sg13cmos5l_decap_4
XFILLER_12_175 VPWR VGND sg13cmos5l_decap_8
XFILLER_12_182 VPWR VGND sg13cmos5l_decap_4
XFILLER_13_0 VPWR VGND sg13cmos5l_decap_8
XFILLER_13_7 VPWR VGND sg13cmos5l_decap_8
XFILLER_13_44 VPWR VGND sg13cmos5l_decap_8
XFILLER_13_51 VPWR VGND sg13cmos5l_decap_8
XFILLER_13_63 VPWR VGND sg13cmos5l_decap_8
XFILLER_13_70 VPWR VGND sg13cmos5l_decap_8
XFILLER_13_77 VPWR VGND sg13cmos5l_decap_8
XFILLER_13_84 VPWR VGND sg13cmos5l_decap_4
XFILLER_13_92 VPWR VGND sg13cmos5l_decap_8
XFILLER_13_99 VPWR VGND sg13cmos5l_decap_8
XFILLER_13_106 VPWR VGND sg13cmos5l_decap_8
XFILLER_13_113 VPWR VGND sg13cmos5l_decap_8
XFILLER_13_131 VPWR VGND sg13cmos5l_decap_8
XFILLER_13_138 VPWR VGND sg13cmos5l_decap_8
XFILLER_13_149 VPWR VGND sg13cmos5l_decap_8
XFILLER_13_175 VPWR VGND sg13cmos5l_decap_8
XFILLER_13_182 VPWR VGND sg13cmos5l_decap_4
XFILLER_14_9 VPWR VGND sg13cmos5l_decap_8
XFILLER_14_31 VPWR VGND sg13cmos5l_decap_8
XFILLER_14_44 VPWR VGND sg13cmos5l_decap_8
XFILLER_14_51 VPWR VGND sg13cmos5l_decap_8
XFILLER_14_68 VPWR VGND sg13cmos5l_decap_4
XFILLER_14_92 VPWR VGND sg13cmos5l_decap_8
XFILLER_14_113 VPWR VGND sg13cmos5l_decap_8
XFILLER_14_134 VPWR VGND sg13cmos5l_decap_8
XFILLER_14_141 VPWR VGND sg13cmos5l_decap_4
XFILLER_14_160 VPWR VGND sg13cmos5l_decap_4
XFILLER_14_175 VPWR VGND sg13cmos5l_decap_8
XFILLER_14_182 VPWR VGND sg13cmos5l_decap_4
XFILLER_15_0 VPWR VGND sg13cmos5l_decap_8
XFILLER_15_7 VPWR VGND sg13cmos5l_decap_8
XFILLER_15_45 VPWR VGND sg13cmos5l_decap_8
XFILLER_15_52 VPWR VGND sg13cmos5l_decap_8
XFILLER_15_72 VPWR VGND sg13cmos5l_decap_8
XFILLER_15_87 VPWR VGND sg13cmos5l_decap_8
XFILLER_15_94 VPWR VGND sg13cmos5l_decap_4
XFILLER_15_132 VPWR VGND sg13cmos5l_decap_8
XFILLER_15_139 VPWR VGND sg13cmos5l_decap_4
XFILLER_15_175 VPWR VGND sg13cmos5l_decap_8
XFILLER_15_182 VPWR VGND sg13cmos5l_decap_4
XFILLER_16_9 VPWR VGND sg13cmos5l_decap_8
XFILLER_16_50 VPWR VGND sg13cmos5l_decap_8
XFILLER_16_76 VPWR VGND sg13cmos5l_decap_4
XFILLER_16_88 VPWR VGND sg13cmos5l_decap_8
XFILLER_16_95 VPWR VGND sg13cmos5l_decap_8
XFILLER_16_102 VPWR VGND sg13cmos5l_decap_4
XFILLER_16_111 VPWR VGND sg13cmos5l_decap_8
XFILLER_16_118 VPWR VGND sg13cmos5l_decap_4
XFILLER_16_126 VPWR VGND sg13cmos5l_decap_4
XFILLER_16_134 VPWR VGND sg13cmos5l_decap_8
XFILLER_16_141 VPWR VGND sg13cmos5l_decap_8
XFILLER_16_148 VPWR VGND sg13cmos5l_decap_8
XFILLER_16_155 VPWR VGND sg13cmos5l_decap_4
XFILLER_16_175 VPWR VGND sg13cmos5l_decap_8
XFILLER_16_182 VPWR VGND sg13cmos5l_decap_4
XFILLER_17_0 VPWR VGND sg13cmos5l_decap_8
XFILLER_17_7 VPWR VGND sg13cmos5l_decap_8
XFILLER_17_44 VPWR VGND sg13cmos5l_decap_8
XFILLER_17_51 VPWR VGND sg13cmos5l_decap_8
XFILLER_17_88 VPWR VGND sg13cmos5l_decap_8
XFILLER_17_95 VPWR VGND sg13cmos5l_decap_8
XFILLER_17_102 VPWR VGND sg13cmos5l_decap_4
XFILLER_17_111 VPWR VGND sg13cmos5l_decap_8
XFILLER_17_134 VPWR VGND sg13cmos5l_decap_8
XFILLER_17_173 VPWR VGND sg13cmos5l_decap_8
XFILLER_17_180 VPWR VGND sg13cmos5l_decap_4
XFILLER_18_0 VPWR VGND sg13cmos5l_decap_8
XFILLER_18_7 VPWR VGND sg13cmos5l_decap_8
XFILLER_18_34 VPWR VGND sg13cmos5l_decap_4
XFILLER_18_50 VPWR VGND sg13cmos5l_decap_8
XFILLER_18_78 VPWR VGND sg13cmos5l_decap_8
XFILLER_18_92 VPWR VGND sg13cmos5l_decap_8
XFILLER_18_133 VPWR VGND sg13cmos5l_decap_8
XFILLER_18_154 VPWR VGND sg13cmos5l_decap_8
XFILLER_18_175 VPWR VGND sg13cmos5l_decap_8
XFILLER_18_182 VPWR VGND sg13cmos5l_decap_4
XFILLER_19_9 VPWR VGND sg13cmos5l_decap_8
XFILLER_19_29 VPWR VGND sg13cmos5l_decap_4
XFILLER_19_46 VPWR VGND sg13cmos5l_decap_8
XFILLER_19_53 VPWR VGND sg13cmos5l_decap_8
XFILLER_19_60 VPWR VGND sg13cmos5l_decap_8
XFILLER_19_67 VPWR VGND sg13cmos5l_decap_8
XFILLER_19_74 VPWR VGND sg13cmos5l_decap_4
XFILLER_19_90 VPWR VGND sg13cmos5l_decap_8
XFILLER_19_133 VPWR VGND sg13cmos5l_decap_8
XFILLER_19_140 VPWR VGND sg13cmos5l_decap_4
XFILLER_19_175 VPWR VGND sg13cmos5l_decap_8
XFILLER_19_182 VPWR VGND sg13cmos5l_decap_4
XFILLER_20_9 VPWR VGND sg13cmos5l_decap_8
XFILLER_20_44 VPWR VGND sg13cmos5l_decap_8
XFILLER_20_51 VPWR VGND sg13cmos5l_decap_8
XFILLER_20_58 VPWR VGND sg13cmos5l_decap_4
XFILLER_20_69 VPWR VGND sg13cmos5l_decap_4
XFILLER_20_86 VPWR VGND sg13cmos5l_decap_8
XFILLER_20_93 VPWR VGND sg13cmos5l_decap_8
XFILLER_20_133 VPWR VGND sg13cmos5l_decap_8
XFILLER_20_140 VPWR VGND sg13cmos5l_decap_4
XFILLER_20_175 VPWR VGND sg13cmos5l_decap_8
XFILLER_20_182 VPWR VGND sg13cmos5l_decap_4
XFILLER_21_0 VPWR VGND sg13cmos5l_decap_4
XFILLER_21_9 VPWR VGND sg13cmos5l_decap_8
XFILLER_21_50 VPWR VGND sg13cmos5l_decap_8
XFILLER_21_92 VPWR VGND sg13cmos5l_decap_8
XFILLER_21_134 VPWR VGND sg13cmos5l_decap_8
XFILLER_21_173 VPWR VGND sg13cmos5l_decap_8
XFILLER_21_180 VPWR VGND sg13cmos5l_decap_4
XFILLER_22_0 VPWR VGND sg13cmos5l_decap_8
XFILLER_22_7 VPWR VGND sg13cmos5l_decap_8
XFILLER_22_23 VPWR VGND sg13cmos5l_decap_4
XFILLER_22_45 VPWR VGND sg13cmos5l_decap_8
XFILLER_22_52 VPWR VGND sg13cmos5l_decap_8
XFILLER_22_59 VPWR VGND sg13cmos5l_decap_8
XFILLER_22_66 VPWR VGND sg13cmos5l_decap_8
XFILLER_22_73 VPWR VGND sg13cmos5l_decap_8
XFILLER_22_80 VPWR VGND sg13cmos5l_decap_4
XFILLER_22_92 VPWR VGND sg13cmos5l_decap_8
XFILLER_22_104 VPWR VGND sg13cmos5l_decap_8
XFILLER_22_111 VPWR VGND sg13cmos5l_decap_8
XFILLER_22_118 VPWR VGND sg13cmos5l_decap_4
XFILLER_22_127 VPWR VGND sg13cmos5l_decap_8
XFILLER_22_134 VPWR VGND sg13cmos5l_decap_8
XFILLER_22_141 VPWR VGND sg13cmos5l_decap_8
XFILLER_22_175 VPWR VGND sg13cmos5l_decap_8
XFILLER_22_182 VPWR VGND sg13cmos5l_decap_4
.ENDS clk_gen

* ===== build/sg13cmos5l/macros/tdc/cdl/tdc.cdl
* CDL Netlist generated by OpenROAD

*.BUSDELIMITER [

.SUBCKT tdc Clk_out Clk_ref Sel Start busy hit tdc_f[0] tdc_f[1]  tdc_f[2] tdc_f[3] tdc_f[4] tdc_f[5] tdc_f[6] tdc_f[7] tdc_s[0]  tdc_s[1] tdc_s[2] tdc_s[3] tdc_s[4] tdc_s[5] tdc_s[6] tdc_s[7]  valid VPWR VGND
Xx1._08_ x1._06_\[0\] net63 VPWR VGND sg13cmos5l_inv_1
Xx1._09_ x1._00_ net63 net60 net62 VPWR VGND sg13cmos5l_nand3_1
Xx1._10_ x1._01_ ccount\[0\] ccount\[1\] ccount\[2\] ccount\[3\]  VPWR VGND sg13cmos5l_and4_1
Xx1._11_ x1._02_ x1._01_ ccount\[5\] ccount\[4\] VPWR VGND  sg13cmos5l_nand3_1
Xx1._12_ x1._03_ x1._01_ ccount\[5\] ccount\[6\] ccount\[4\]  VPWR VGND sg13cmos5l_nand4_1
Xx1._13_ x1._07_\[7\] x1._03_ ccount\[7\] VPWR VGND sg13cmos5l_xnor2_1
Xx1._14_ x1._07_\[6\] ccount\[6\] x1._02_ VPWR VGND sg13cmos5l_xnor2_1
Xx1._15_ x1._04_ ccount\[4\] x1._01_ ccount\[5\] VPWR VGND  sg13cmos5l_a21o_1
Xx1._16_ x1._07_\[5\] x1._02_ x1._04_ VPWR VGND sg13cmos5l_and2_1
Xx1._17_ x1._07_\[4\] ccount\[4\] x1._01_ VPWR VGND sg13cmos5l_xor2_1
Xx1._18_ x1._07_\[3\] x1._00_ net61 VPWR VGND sg13cmos5l_xnor2_1
Xx1._19_ x1._05_ net60 net63 net62 VPWR VGND sg13cmos5l_a21o_1
Xx1._20_ x1._07_\[2\] x1._00_ x1._05_ VPWR VGND sg13cmos5l_and2_1
Xx1._21_ x1._07_\[1\] net60 net63 VPWR VGND sg13cmos5l_xor2_1
Xx1._22_ ccount\[0\] OS x1._06_\[0\] net29 VPWR VGND sg13cmos5l_dfrbpq_2
Xx1._23_ ccount\[1\] OS x1._07_\[1\] net29 VPWR VGND sg13cmos5l_dfrbpq_2
Xx1._24_ ccount\[2\] OS x1._07_\[2\] net29 VPWR VGND sg13cmos5l_dfrbpq_2
Xx1._25_ ccount\[3\] OS x1._07_\[3\] net29 VPWR VGND sg13cmos5l_dfrbpq_2
Xx1._26_ ccount\[4\] OS x1._07_\[4\] net29 VPWR VGND sg13cmos5l_dfrbpq_1
Xx1._27_ ccount\[5\] OS x1._07_\[5\] net29 VPWR VGND sg13cmos5l_dfrbpq_1
Xx1._28_ ccount\[6\] OS x1._07_\[6\] net29 VPWR VGND sg13cmos5l_dfrbpq_1
Xx1._29_ ccount\[7\] OS x1._07_\[7\] net29 VPWR VGND sg13cmos5l_dfrbpq_1
Xx10 net3 net34 net4 net5 VPWR VGND sg13cmos5l_and3_1
Xx11 net4 Detect VPWR VGND sg13cmos5l_inv_1
Xx12 net5 hit_raw VPWR VGND sg13cmos5l_inv_1
Xx3.x6_37 net44 VPWR VGND sg13cmos5l_tiehi
Xx14.x1 hit_raw x14.net3 FO_enable net30 VPWR VGND sg13cmos5l_dfrbpq_1
Xx14.x2 x14.net1 SO_enable VPWR VGND sg13cmos5l_dlygate4sd3_1
Xx14.x3 x14.net2 x14.net1 VPWR VGND sg13cmos5l_dlygate4sd2_1
Xx14.x4 x14.net3 x14.net2 VPWR VGND sg13cmos5l_dlygate4sd2_1
Xx15 cap_clk Detect hit_raw VPWR VGND sg13cmos5l_or2_1
Xx16 net10 Reset VPWR VGND sg13cmos5l_buf_1
Xx2._08_ x2._06_\[0\] net59 VPWR VGND sg13cmos5l_inv_1
Xx2._09_ x2._00_ net59 net56 net58 VPWR VGND sg13cmos5l_nand3_1
Xx2._10_ x2._01_ fcount\[0\] fcount\[1\] fcount\[2\] fcount\[3\]  VPWR VGND sg13cmos5l_and4_1
Xx2._11_ x2._02_ fcount\[4\] x2._01_ fcount\[5\] VPWR VGND  sg13cmos5l_nand3_1
Xx2._12_ x2._03_ x2._01_ fcount\[5\] fcount\[6\] fcount\[4\]  VPWR VGND sg13cmos5l_nand4_1
Xx2._13_ x2._07_\[7\] fcount\[7\] x2._03_ VPWR VGND sg13cmos5l_xnor2_1
Xx2._14_ x2._07_\[6\] x2._02_ fcount\[6\] VPWR VGND sg13cmos5l_xnor2_1
Xx2._15_ x2._04_ fcount\[4\] x2._01_ fcount\[5\] VPWR VGND  sg13cmos5l_a21o_1
Xx2._16_ x2._07_\[5\] x2._04_ x2._02_ VPWR VGND sg13cmos5l_and2_1
Xx2._17_ x2._07_\[4\] fcount\[4\] net55 VPWR VGND sg13cmos5l_xor2_1
Xx2._18_ x2._07_\[3\] net57 x2._00_ VPWR VGND sg13cmos5l_xnor2_1
Xx2._19_ x2._05_ net56 net59 net58 VPWR VGND sg13cmos5l_a21o_1
Xx2._20_ x2._07_\[2\] x2._00_ x2._05_ VPWR VGND sg13cmos5l_and2_1
Xx2._21_ x2._07_\[1\] net56 net59 VPWR VGND sg13cmos5l_xor2_1
Xx2._22_ fcount\[0\] OF x2._06_\[0\] net31 VPWR VGND sg13cmos5l_dfrbpq_2
Xx2._23_ fcount\[1\] OF x2._07_\[1\] net31 VPWR VGND sg13cmos5l_dfrbpq_2
Xx2._24_ fcount\[2\] OF x2._07_\[2\] net31 VPWR VGND sg13cmos5l_dfrbpq_2
Xx2._25_ fcount\[3\] OF x2._07_\[3\] net31 VPWR VGND sg13cmos5l_dfrbpq_2
Xx2._26_ fcount\[4\] OF x2._07_\[4\] net31 VPWR VGND sg13cmos5l_dfrbpq_1
Xx2._27_ fcount\[5\] OF x2._07_\[5\] net31 VPWR VGND sg13cmos5l_dfrbpq_1
Xx2._28_ fcount\[6\] OF x2._07_\[6\] net31 VPWR VGND sg13cmos5l_dfrbpq_1
Xx2._29_ fcount\[7\] OF x2._07_\[7\] net31 VPWR VGND sg13cmos5l_dfrbpq_1
Xx3.x3 x3.q1 x3.net2 OF OS net30 VPWR VGND sg13cmos5l_dfrbp_1
Xx3.x4 x3.q2 x3.net3 OF x3.q1 net30 VPWR VGND sg13cmos5l_dfrbp_1
Xx3.x5 x3.net1 x3.q1 x3.q2 VPWR VGND sg13cmos5l_nand2_1
Xx3.x6 Detect x3.net4 x3.net1 net44 net30 VPWR VGND sg13cmos5l_dfrbp_1
Xx4.xc0_38 net45 VPWR VGND sg13cmos5l_tiehi
Xx4.x0 x4.n0 FO_enable x4.n6 VPWR VGND sg13cmos5l_nand2_1
Xx4.x1 x4.n1 x4.n0 VPWR VGND sg13cmos5l_buf_1
Xx4.x2 x4.n2 x4.n1 VPWR VGND sg13cmos5l_buf_1
Xx4.x3 x4.n3 x4.n2 VPWR VGND sg13cmos5l_buf_1
Xx4.x4 x4.n4 x4.n3 VPWR VGND sg13cmos5l_buf_1
Xx4.x5 x4.n5 x4.n4 VPWR VGND sg13cmos5l_buf_1
Xx4.x6 x4.n6 x4.n5 VPWR VGND sg13cmos5l_buf_1
Xx4.xc0 x4.n6 net45 VPWR VGND custom_cap_4
Xx4.xc1 x4.n6 net46 VPWR VGND custom_cap_4
Xx4.xc2 x4.n6 net47 VPWR VGND custom_cap_4
Xx4.xc3 x4.n6 net48 VPWR VGND custom_cap_4
Xx4.xc4 x4.n6 net49 VPWR VGND custom_cap_4
Xx4.xc5 x4.n6 net50 VPWR VGND custom_cap_4
Xx4.xc6 x4.n6 net51 VPWR VGND custom_cap_4
Xx4.xc7 x4.n6 net52 VPWR VGND custom_cap_4
Xx4.xo OF x4.n6 VPWR VGND sg13cmos5l_buf_4
Xx5.xc0_46 net53 VPWR VGND sg13cmos5l_tiehi
Xx5.xc2_27 net VPWR VGND sg13cmos5l_tielo
Xx5.x0 x5.n0 SO_enable x5.n6 VPWR VGND sg13cmos5l_nand2_1
Xx5.x1 x5.n1 x5.n0 VPWR VGND sg13cmos5l_buf_1
Xx5.x2 x5.n2 x5.n1 VPWR VGND sg13cmos5l_buf_1
Xx5.x3 x5.n3 x5.n2 VPWR VGND sg13cmos5l_buf_1
Xx5.x4 x5.n4 x5.n3 VPWR VGND sg13cmos5l_buf_1
Xx5.x5 x5.n5 x5.n4 VPWR VGND sg13cmos5l_buf_1
Xx5.x6 x5.n6 x5.n5 VPWR VGND sg13cmos5l_buf_1
Xx5.xc0 x5.n6 net53 VPWR VGND custom_cap_4
Xx5.xc1 x5.n6 net54 VPWR VGND custom_cap_4
Xx5.xc2 x5.n6 net VPWR VGND custom_cap_4
Xx5.xc3 x5.n6 net35 VPWR VGND custom_cap_4
Xx5.xc4 x5.n6 net36 VPWR VGND custom_cap_4
Xx5.xc5 x5.n6 net37 VPWR VGND custom_cap_4
Xx5.xc6 x5.n6 net38 VPWR VGND custom_cap_4
Xx5.xc7 x5.n6 net39 VPWR VGND custom_cap_4
Xx5.xo OS x5.n6 VPWR VGND sg13cmos5l_buf_4
Xrebuffer48 net55 x2._01_ VPWR VGND sg13cmos5l_buf_1
Xx6_33 net40 VPWR VGND sg13cmos5l_tiehi
Xx6 SO_enable net6 Clk_out net40 net30 VPWR VGND sg13cmos5l_dfrbp_1
Xx7 FO_enable net7 Clk_ref net41 net30 VPWR VGND sg13cmos5l_dfrbp_1
Xx8 net2 net1 Sel net66 net34 VPWR VGND sg13cmos5l_dfrbp_1
Xx9 Reset net8 net2 net42 net3 VPWR VGND sg13cmos5l_dfrbp_1
Xxcf_0 net12 cap_clk net59 net33 VPWR VGND sg13cmos5l_dfrbpq_1
Xxcf_1 net13 cap_clk net56 net33 VPWR VGND sg13cmos5l_dfrbpq_1
Xxcf_2 net14 cap_clk net58 net33 VPWR VGND sg13cmos5l_dfrbpq_1
Xxcf_3 net15 cap_clk net57 net33 VPWR VGND sg13cmos5l_dfrbpq_1
Xxcf_4 net16 cap_clk fcount\[4\] net33 VPWR VGND sg13cmos5l_dfrbpq_1
Xxcf_5 net17 cap_clk fcount\[5\] net33 VPWR VGND sg13cmos5l_dfrbpq_1
Xxcf_6 net18 cap_clk fcount\[6\] net33 VPWR VGND sg13cmos5l_dfrbpq_1
Xxcf_7 net19 cap_clk fcount\[7\] net33 VPWR VGND sg13cmos5l_dfrbpq_1
Xxch net11 cap_clk hit_raw net34 VPWR VGND sg13cmos5l_dfrbpq_1
Xxcs_0 net20 cap_clk net63 net32 VPWR VGND sg13cmos5l_dfrbpq_1
Xxcs_1 net21 cap_clk net60 net32 VPWR VGND sg13cmos5l_dfrbpq_1
Xxcs_2 net22 cap_clk net62 net32 VPWR VGND sg13cmos5l_dfrbpq_1
Xxcs_3 net23 cap_clk net61 net32 VPWR VGND sg13cmos5l_dfrbpq_1
Xxcs_4 net24 cap_clk ccount\[4\] net32 VPWR VGND sg13cmos5l_dfrbpq_1
Xxcs_5 net25 cap_clk ccount\[5\] net32 VPWR VGND sg13cmos5l_dfrbpq_1
Xxcs_6 net26 cap_clk ccount\[6\] net32 VPWR VGND sg13cmos5l_dfrbpq_1
Xxcs_7 net27 cap_clk ccount\[7\] net32 VPWR VGND sg13cmos5l_dfrbpq_1
Xxcv net28 cap_clk net43 net34 VPWR VGND sg13cmos5l_dfrbpq_1
Xinput1 net9 Start VPWR VGND sg13cmos5l_buf_1
Xoutput2 busy net10 VPWR VGND sg13cmos5l_buf_1
Xoutput3 hit net11 VPWR VGND sg13cmos5l_buf_1
Xoutput4 tdc_f[0] net12 VPWR VGND sg13cmos5l_buf_1
Xoutput5 tdc_f[1] net13 VPWR VGND sg13cmos5l_buf_1
Xoutput6 tdc_f[2] net14 VPWR VGND sg13cmos5l_buf_1
Xoutput7 tdc_f[3] net15 VPWR VGND sg13cmos5l_buf_1
Xoutput8 tdc_f[4] net16 VPWR VGND sg13cmos5l_buf_1
Xoutput9 tdc_f[5] net17 VPWR VGND sg13cmos5l_buf_1
Xoutput10 tdc_f[6] net18 VPWR VGND sg13cmos5l_buf_1
Xoutput11 tdc_f[7] net19 VPWR VGND sg13cmos5l_buf_1
Xoutput12 tdc_s[0] net20 VPWR VGND sg13cmos5l_buf_1
Xoutput13 tdc_s[1] net21 VPWR VGND sg13cmos5l_buf_1
Xoutput14 tdc_s[2] net22 VPWR VGND sg13cmos5l_buf_1
Xoutput15 tdc_s[3] net23 VPWR VGND sg13cmos5l_buf_1
Xoutput16 tdc_s[4] net24 VPWR VGND sg13cmos5l_buf_1
Xoutput17 tdc_s[5] net25 VPWR VGND sg13cmos5l_buf_1
Xoutput18 tdc_s[6] net26 VPWR VGND sg13cmos5l_buf_1
Xoutput19 tdc_s[7] net27 VPWR VGND sg13cmos5l_buf_1
Xoutput20 valid net28 VPWR VGND sg13cmos5l_buf_1
Xfanout21 net29 net30 VPWR VGND sg13cmos5l_buf_1
Xfanout22 net30 Reset VPWR VGND sg13cmos5l_buf_1
Xfanout23 net31 Reset VPWR VGND sg13cmos5l_buf_1
Xfanout24 net32 net34 VPWR VGND sg13cmos5l_buf_1
Xfanout25 net33 net34 VPWR VGND sg13cmos5l_buf_1
Xfanout26 net34 net9 VPWR VGND sg13cmos5l_buf_1
Xx5.xc3_28 net35 VPWR VGND sg13cmos5l_tielo
Xx5.xc4_29 net36 VPWR VGND sg13cmos5l_tielo
Xx5.xc5_30 net37 VPWR VGND sg13cmos5l_tielo
Xx5.xc6_31 net38 VPWR VGND sg13cmos5l_tielo
Xx5.xc7_32 net39 VPWR VGND sg13cmos5l_tielo
Xx7_34 net41 VPWR VGND sg13cmos5l_tiehi
Xx9_35 net42 VPWR VGND sg13cmos5l_tiehi
Xxcv_36 net43 VPWR VGND sg13cmos5l_tiehi
Xx4.xc1_39 net46 VPWR VGND sg13cmos5l_tiehi
Xx4.xc2_40 net47 VPWR VGND sg13cmos5l_tiehi
Xx4.xc3_41 net48 VPWR VGND sg13cmos5l_tiehi
Xx4.xc4_42 net49 VPWR VGND sg13cmos5l_tiehi
Xx4.xc5_43 net50 VPWR VGND sg13cmos5l_tiehi
Xx4.xc6_44 net51 VPWR VGND sg13cmos5l_tiehi
Xx4.xc7_45 net52 VPWR VGND sg13cmos5l_tiehi
Xx5.xc1_47 net54 VPWR VGND sg13cmos5l_tiehi
Xrebuffer49 net56 fcount\[1\] VPWR VGND sg13cmos5l_buf_1
Xrebuffer50 net57 fcount\[3\] VPWR VGND sg13cmos5l_buf_1
Xrebuffer51 net58 fcount\[2\] VPWR VGND sg13cmos5l_buf_1
Xrebuffer52 net59 fcount\[0\] VPWR VGND sg13cmos5l_buf_1
Xrebuffer53 net60 ccount\[1\] VPWR VGND sg13cmos5l_buf_8
Xrebuffer54 net61 ccount\[3\] VPWR VGND sg13cmos5l_buf_1
Xrebuffer55 net62 ccount\[2\] VPWR VGND sg13cmos5l_buf_8
Xrebuffer56 net63 ccount\[0\] VPWR VGND sg13cmos5l_buf_8
Xhold59 net66 net1 VPWR VGND sg13cmos5l_dlygate4sd3_1
XFILLER_0_9 VPWR VGND sg13cmos5l_decap_8
XFILLER_0_48 VPWR VGND sg13cmos5l_decap_8
XFILLER_0_55 VPWR VGND sg13cmos5l_decap_4
XFILLER_0_69 VPWR VGND sg13cmos5l_decap_8
XFILLER_0_81 VPWR VGND sg13cmos5l_decap_8
XFILLER_0_92 VPWR VGND sg13cmos5l_decap_8
XFILLER_0_131 VPWR VGND sg13cmos5l_decap_8
XFILLER_0_138 VPWR VGND sg13cmos5l_decap_4
XFILLER_0_175 VPWR VGND sg13cmos5l_decap_8
XFILLER_1_0 VPWR VGND sg13cmos5l_decap_8
XFILLER_1_7 VPWR VGND sg13cmos5l_decap_8
XFILLER_1_48 VPWR VGND sg13cmos5l_decap_8
XFILLER_1_55 VPWR VGND sg13cmos5l_decap_4
XFILLER_1_86 VPWR VGND sg13cmos5l_decap_8
XFILLER_1_93 VPWR VGND sg13cmos5l_decap_8
XFILLER_1_134 VPWR VGND sg13cmos5l_decap_8
XFILLER_1_175 VPWR VGND sg13cmos5l_decap_8
XFILLER_2_0 VPWR VGND sg13cmos5l_decap_8
XFILLER_2_7 VPWR VGND sg13cmos5l_decap_8
XFILLER_2_14 VPWR VGND sg13cmos5l_decap_8
XFILLER_2_50 VPWR VGND sg13cmos5l_decap_8
XFILLER_2_57 VPWR VGND sg13cmos5l_decap_8
XFILLER_2_92 VPWR VGND sg13cmos5l_decap_8
XFILLER_2_99 VPWR VGND sg13cmos5l_decap_4
XFILLER_2_132 VPWR VGND sg13cmos5l_decap_8
XFILLER_2_139 VPWR VGND sg13cmos5l_decap_4
XFILLER_2_175 VPWR VGND sg13cmos5l_decap_8
XFILLER_2_182 VPWR VGND sg13cmos5l_decap_8
XFILLER_3_0 VPWR VGND sg13cmos5l_decap_8
XFILLER_3_7 VPWR VGND sg13cmos5l_decap_8
XFILLER_3_44 VPWR VGND sg13cmos5l_decap_8
XFILLER_3_51 VPWR VGND sg13cmos5l_decap_8
XFILLER_3_92 VPWR VGND sg13cmos5l_decap_8
XFILLER_3_127 VPWR VGND sg13cmos5l_decap_8
XFILLER_3_134 VPWR VGND sg13cmos5l_decap_8
XFILLER_3_175 VPWR VGND sg13cmos5l_decap_8
XFILLER_3_182 VPWR VGND sg13cmos5l_decap_8
XFILLER_4_0 VPWR VGND sg13cmos5l_decap_8
XFILLER_4_7 VPWR VGND sg13cmos5l_decap_8
XFILLER_4_44 VPWR VGND sg13cmos5l_decap_8
XFILLER_4_51 VPWR VGND sg13cmos5l_decap_8
XFILLER_4_66 VPWR VGND sg13cmos5l_decap_4
XFILLER_4_74 VPWR VGND sg13cmos5l_decap_8
XFILLER_4_81 VPWR VGND sg13cmos5l_decap_8
XFILLER_4_88 VPWR VGND sg13cmos5l_decap_8
XFILLER_4_95 VPWR VGND sg13cmos5l_decap_8
XFILLER_4_110 VPWR VGND sg13cmos5l_decap_8
XFILLER_4_117 VPWR VGND sg13cmos5l_decap_8
XFILLER_4_124 VPWR VGND sg13cmos5l_decap_8
XFILLER_4_131 VPWR VGND sg13cmos5l_decap_8
XFILLER_4_138 VPWR VGND sg13cmos5l_decap_4
XFILLER_4_174 VPWR VGND sg13cmos5l_decap_8
XFILLER_4_181 VPWR VGND sg13cmos5l_decap_8
XFILLER_5_0 VPWR VGND sg13cmos5l_decap_8
XFILLER_5_7 VPWR VGND sg13cmos5l_decap_8
XFILLER_5_25 VPWR VGND sg13cmos5l_decap_8
XFILLER_5_32 VPWR VGND sg13cmos5l_decap_8
XFILLER_5_50 VPWR VGND sg13cmos5l_decap_8
XFILLER_5_71 VPWR VGND sg13cmos5l_decap_8
XFILLER_5_78 VPWR VGND sg13cmos5l_decap_4
XFILLER_5_92 VPWR VGND sg13cmos5l_decap_8
XFILLER_5_127 VPWR VGND sg13cmos5l_decap_8
XFILLER_5_134 VPWR VGND sg13cmos5l_decap_8
XFILLER_5_175 VPWR VGND sg13cmos5l_decap_8
XFILLER_5_182 VPWR VGND sg13cmos5l_decap_8
XFILLER_6_0 VPWR VGND sg13cmos5l_decap_8
XFILLER_6_7 VPWR VGND sg13cmos5l_decap_8
XFILLER_6_50 VPWR VGND sg13cmos5l_decap_8
XFILLER_6_87 VPWR VGND sg13cmos5l_decap_8
XFILLER_6_94 VPWR VGND sg13cmos5l_decap_8
XFILLER_6_116 VPWR VGND sg13cmos5l_decap_8
XFILLER_6_123 VPWR VGND sg13cmos5l_decap_8
XFILLER_6_130 VPWR VGND sg13cmos5l_decap_8
XFILLER_6_137 VPWR VGND sg13cmos5l_decap_4
XFILLER_6_174 VPWR VGND sg13cmos5l_decap_8
XFILLER_6_181 VPWR VGND sg13cmos5l_decap_8
XFILLER_7_0 VPWR VGND sg13cmos5l_decap_8
XFILLER_7_7 VPWR VGND sg13cmos5l_decap_8
XFILLER_7_23 VPWR VGND sg13cmos5l_decap_8
XFILLER_7_30 VPWR VGND sg13cmos5l_decap_8
XFILLER_7_37 VPWR VGND sg13cmos5l_decap_8
XFILLER_7_44 VPWR VGND sg13cmos5l_decap_8
XFILLER_7_51 VPWR VGND sg13cmos5l_decap_8
XFILLER_7_87 VPWR VGND sg13cmos5l_decap_8
XFILLER_7_94 VPWR VGND sg13cmos5l_decap_4
XFILLER_7_127 VPWR VGND sg13cmos5l_decap_8
XFILLER_7_134 VPWR VGND sg13cmos5l_decap_8
XFILLER_7_141 VPWR VGND sg13cmos5l_decap_4
XFILLER_7_175 VPWR VGND sg13cmos5l_decap_8
XFILLER_7_182 VPWR VGND sg13cmos5l_decap_8
XFILLER_8_0 VPWR VGND sg13cmos5l_decap_8
XFILLER_8_7 VPWR VGND sg13cmos5l_decap_8
XFILLER_8_30 VPWR VGND sg13cmos5l_decap_8
XFILLER_8_37 VPWR VGND sg13cmos5l_decap_8
XFILLER_8_44 VPWR VGND sg13cmos5l_decap_8
XFILLER_8_51 VPWR VGND sg13cmos5l_decap_8
XFILLER_8_92 VPWR VGND sg13cmos5l_decap_8
XFILLER_8_132 VPWR VGND sg13cmos5l_decap_8
XFILLER_8_139 VPWR VGND sg13cmos5l_decap_4
XFILLER_8_158 VPWR VGND sg13cmos5l_decap_8
XFILLER_8_170 VPWR VGND sg13cmos5l_decap_8
XFILLER_8_177 VPWR VGND sg13cmos5l_decap_8
XFILLER_8_184 VPWR VGND sg13cmos5l_decap_8
XFILLER_9_9 VPWR VGND sg13cmos5l_decap_8
XFILLER_9_44 VPWR VGND sg13cmos5l_decap_8
XFILLER_9_51 VPWR VGND sg13cmos5l_decap_8
XFILLER_9_58 VPWR VGND sg13cmos5l_decap_4
XFILLER_9_92 VPWR VGND sg13cmos5l_decap_8
XFILLER_9_99 VPWR VGND sg13cmos5l_decap_4
XFILLER_9_130 VPWR VGND sg13cmos5l_decap_8
XFILLER_9_137 VPWR VGND sg13cmos5l_decap_4
XFILLER_9_170 VPWR VGND sg13cmos5l_decap_8
XFILLER_9_177 VPWR VGND sg13cmos5l_decap_8
XFILLER_9_184 VPWR VGND sg13cmos5l_decap_8
XFILLER_10_9 VPWR VGND sg13cmos5l_decap_8
XFILLER_10_50 VPWR VGND sg13cmos5l_decap_8
XFILLER_10_92 VPWR VGND sg13cmos5l_decap_8
XFILLER_10_112 VPWR VGND sg13cmos5l_decap_8
XFILLER_10_119 VPWR VGND sg13cmos5l_decap_8
XFILLER_10_126 VPWR VGND sg13cmos5l_decap_8
XFILLER_10_133 VPWR VGND sg13cmos5l_decap_8
XFILLER_10_140 VPWR VGND sg13cmos5l_decap_8
XFILLER_10_147 VPWR VGND sg13cmos5l_decap_8
XFILLER_10_154 VPWR VGND sg13cmos5l_decap_8
XFILLER_10_161 VPWR VGND sg13cmos5l_decap_8
XFILLER_10_168 VPWR VGND sg13cmos5l_decap_8
XFILLER_10_175 VPWR VGND sg13cmos5l_decap_8
XFILLER_10_182 VPWR VGND sg13cmos5l_decap_8
XFILLER_11_0 VPWR VGND sg13cmos5l_decap_4
XFILLER_11_9 VPWR VGND sg13cmos5l_decap_8
XFILLER_11_50 VPWR VGND sg13cmos5l_decap_8
XFILLER_11_87 VPWR VGND sg13cmos5l_decap_8
XFILLER_11_94 VPWR VGND sg13cmos5l_decap_8
XFILLER_11_101 VPWR VGND sg13cmos5l_decap_8
XFILLER_11_108 VPWR VGND sg13cmos5l_decap_8
XFILLER_11_115 VPWR VGND sg13cmos5l_decap_8
XFILLER_11_122 VPWR VGND sg13cmos5l_decap_8
XFILLER_11_129 VPWR VGND sg13cmos5l_decap_8
XFILLER_11_136 VPWR VGND sg13cmos5l_decap_8
XFILLER_11_143 VPWR VGND sg13cmos5l_decap_8
XFILLER_11_150 VPWR VGND sg13cmos5l_decap_8
XFILLER_11_157 VPWR VGND sg13cmos5l_decap_8
XFILLER_11_164 VPWR VGND sg13cmos5l_decap_8
XFILLER_11_171 VPWR VGND sg13cmos5l_decap_8
XFILLER_11_178 VPWR VGND sg13cmos5l_decap_8
XFILLER_11_185 VPWR VGND sg13cmos5l_decap_4
XFILLER_12_0 VPWR VGND sg13cmos5l_decap_8
XFILLER_12_7 VPWR VGND sg13cmos5l_decap_8
XFILLER_12_14 VPWR VGND sg13cmos5l_decap_8
XFILLER_12_21 VPWR VGND sg13cmos5l_decap_8
XFILLER_12_28 VPWR VGND sg13cmos5l_decap_8
XFILLER_12_35 VPWR VGND sg13cmos5l_decap_8
XFILLER_12_42 VPWR VGND sg13cmos5l_decap_8
XFILLER_12_49 VPWR VGND sg13cmos5l_decap_8
XFILLER_12_56 VPWR VGND sg13cmos5l_decap_8
XFILLER_12_63 VPWR VGND sg13cmos5l_decap_8
XFILLER_12_70 VPWR VGND sg13cmos5l_decap_8
XFILLER_12_77 VPWR VGND sg13cmos5l_decap_8
XFILLER_12_84 VPWR VGND sg13cmos5l_decap_8
XFILLER_12_91 VPWR VGND sg13cmos5l_decap_8
XFILLER_12_98 VPWR VGND sg13cmos5l_decap_8
XFILLER_12_105 VPWR VGND sg13cmos5l_decap_8
XFILLER_12_112 VPWR VGND sg13cmos5l_decap_8
XFILLER_12_119 VPWR VGND sg13cmos5l_decap_8
XFILLER_12_126 VPWR VGND sg13cmos5l_decap_8
XFILLER_12_133 VPWR VGND sg13cmos5l_decap_8
XFILLER_12_140 VPWR VGND sg13cmos5l_decap_8
XFILLER_12_147 VPWR VGND sg13cmos5l_decap_8
XFILLER_12_154 VPWR VGND sg13cmos5l_decap_8
XFILLER_12_161 VPWR VGND sg13cmos5l_decap_8
XFILLER_12_168 VPWR VGND sg13cmos5l_decap_8
XFILLER_12_175 VPWR VGND sg13cmos5l_decap_8
XFILLER_12_182 VPWR VGND sg13cmos5l_decap_8
XFILLER_13_0 VPWR VGND sg13cmos5l_decap_8
XFILLER_13_7 VPWR VGND sg13cmos5l_decap_8
XFILLER_13_14 VPWR VGND sg13cmos5l_decap_8
XFILLER_13_21 VPWR VGND sg13cmos5l_decap_8
XFILLER_13_28 VPWR VGND sg13cmos5l_decap_8
XFILLER_13_35 VPWR VGND sg13cmos5l_decap_8
XFILLER_13_50 VPWR VGND sg13cmos5l_decap_8
XFILLER_13_57 VPWR VGND sg13cmos5l_decap_4
XFILLER_13_92 VPWR VGND sg13cmos5l_decap_8
XFILLER_13_99 VPWR VGND sg13cmos5l_decap_8
XFILLER_13_106 VPWR VGND sg13cmos5l_decap_4
XFILLER_13_121 VPWR VGND sg13cmos5l_decap_8
XFILLER_13_128 VPWR VGND sg13cmos5l_decap_8
XFILLER_13_135 VPWR VGND sg13cmos5l_decap_8
XFILLER_13_142 VPWR VGND sg13cmos5l_decap_8
XFILLER_13_149 VPWR VGND sg13cmos5l_decap_8
XFILLER_13_156 VPWR VGND sg13cmos5l_decap_8
XFILLER_13_163 VPWR VGND sg13cmos5l_decap_8
XFILLER_13_170 VPWR VGND sg13cmos5l_decap_8
XFILLER_13_177 VPWR VGND sg13cmos5l_decap_8
XFILLER_13_184 VPWR VGND sg13cmos5l_decap_8
XFILLER_14_0 VPWR VGND sg13cmos5l_decap_8
XFILLER_14_7 VPWR VGND sg13cmos5l_decap_8
XFILLER_14_14 VPWR VGND sg13cmos5l_decap_8
XFILLER_14_21 VPWR VGND sg13cmos5l_decap_8
XFILLER_14_28 VPWR VGND sg13cmos5l_decap_8
XFILLER_14_35 VPWR VGND sg13cmos5l_decap_4
XFILLER_14_50 VPWR VGND sg13cmos5l_decap_8
XFILLER_14_57 VPWR VGND sg13cmos5l_decap_4
XFILLER_14_92 VPWR VGND sg13cmos5l_decap_8
XFILLER_14_129 VPWR VGND sg13cmos5l_decap_8
XFILLER_14_136 VPWR VGND sg13cmos5l_decap_8
XFILLER_14_143 VPWR VGND sg13cmos5l_decap_8
XFILLER_14_150 VPWR VGND sg13cmos5l_decap_8
XFILLER_14_157 VPWR VGND sg13cmos5l_decap_8
XFILLER_14_164 VPWR VGND sg13cmos5l_decap_8
XFILLER_14_171 VPWR VGND sg13cmos5l_decap_8
XFILLER_14_178 VPWR VGND sg13cmos5l_decap_8
XFILLER_14_185 VPWR VGND sg13cmos5l_decap_4
XFILLER_15_0 VPWR VGND sg13cmos5l_decap_8
XFILLER_15_7 VPWR VGND sg13cmos5l_decap_8
XFILLER_15_14 VPWR VGND sg13cmos5l_decap_8
XFILLER_15_21 VPWR VGND sg13cmos5l_decap_8
XFILLER_15_50 VPWR VGND sg13cmos5l_decap_8
XFILLER_15_67 VPWR VGND sg13cmos5l_decap_8
XFILLER_15_74 VPWR VGND sg13cmos5l_decap_8
XFILLER_15_81 VPWR VGND sg13cmos5l_decap_8
XFILLER_15_92 VPWR VGND sg13cmos5l_decap_8
XFILLER_15_131 VPWR VGND sg13cmos5l_decap_8
XFILLER_15_138 VPWR VGND sg13cmos5l_decap_8
XFILLER_15_145 VPWR VGND sg13cmos5l_decap_8
XFILLER_15_152 VPWR VGND sg13cmos5l_decap_8
XFILLER_15_159 VPWR VGND sg13cmos5l_decap_8
XFILLER_15_166 VPWR VGND sg13cmos5l_decap_8
XFILLER_15_173 VPWR VGND sg13cmos5l_decap_8
XFILLER_15_180 VPWR VGND sg13cmos5l_decap_8
XFILLER_15_187 VPWR VGND sg13cmos5l_decap_4
XFILLER_16_0 VPWR VGND sg13cmos5l_decap_8
XFILLER_16_7 VPWR VGND sg13cmos5l_decap_8
XFILLER_16_14 VPWR VGND sg13cmos5l_decap_8
XFILLER_16_50 VPWR VGND sg13cmos5l_decap_8
XFILLER_16_92 VPWR VGND sg13cmos5l_decap_8
XFILLER_16_99 VPWR VGND sg13cmos5l_decap_4
XFILLER_16_133 VPWR VGND sg13cmos5l_decap_8
XFILLER_16_140 VPWR VGND sg13cmos5l_decap_8
XFILLER_16_147 VPWR VGND sg13cmos5l_decap_8
XFILLER_16_154 VPWR VGND sg13cmos5l_decap_8
XFILLER_16_161 VPWR VGND sg13cmos5l_decap_8
XFILLER_16_168 VPWR VGND sg13cmos5l_decap_8
XFILLER_16_175 VPWR VGND sg13cmos5l_decap_8
XFILLER_16_182 VPWR VGND sg13cmos5l_decap_8
XFILLER_17_0 VPWR VGND sg13cmos5l_decap_8
XFILLER_17_7 VPWR VGND sg13cmos5l_decap_8
XFILLER_17_14 VPWR VGND sg13cmos5l_decap_8
XFILLER_17_21 VPWR VGND sg13cmos5l_decap_8
XFILLER_17_50 VPWR VGND sg13cmos5l_decap_8
XFILLER_17_67 VPWR VGND sg13cmos5l_decap_8
XFILLER_17_78 VPWR VGND sg13cmos5l_decap_8
XFILLER_17_85 VPWR VGND sg13cmos5l_decap_8
XFILLER_17_92 VPWR VGND sg13cmos5l_decap_8
XFILLER_17_99 VPWR VGND sg13cmos5l_decap_8
XFILLER_17_125 VPWR VGND sg13cmos5l_decap_8
XFILLER_17_132 VPWR VGND sg13cmos5l_decap_8
XFILLER_17_139 VPWR VGND sg13cmos5l_decap_8
XFILLER_17_146 VPWR VGND sg13cmos5l_decap_8
XFILLER_17_153 VPWR VGND sg13cmos5l_decap_8
XFILLER_17_160 VPWR VGND sg13cmos5l_decap_8
XFILLER_17_167 VPWR VGND sg13cmos5l_decap_8
XFILLER_17_174 VPWR VGND sg13cmos5l_decap_8
XFILLER_17_181 VPWR VGND sg13cmos5l_decap_8
XFILLER_18_0 VPWR VGND sg13cmos5l_decap_8
XFILLER_18_7 VPWR VGND sg13cmos5l_decap_8
XFILLER_18_14 VPWR VGND sg13cmos5l_decap_8
XFILLER_18_21 VPWR VGND sg13cmos5l_decap_8
XFILLER_18_28 VPWR VGND sg13cmos5l_decap_8
XFILLER_18_35 VPWR VGND sg13cmos5l_decap_4
XFILLER_18_50 VPWR VGND sg13cmos5l_decap_8
XFILLER_18_71 VPWR VGND sg13cmos5l_decap_8
XFILLER_18_78 VPWR VGND sg13cmos5l_decap_8
XFILLER_18_85 VPWR VGND sg13cmos5l_decap_8
XFILLER_18_92 VPWR VGND sg13cmos5l_decap_8
XFILLER_18_106 VPWR VGND sg13cmos5l_decap_8
XFILLER_18_120 VPWR VGND sg13cmos5l_decap_8
XFILLER_18_127 VPWR VGND sg13cmos5l_decap_8
XFILLER_18_134 VPWR VGND sg13cmos5l_decap_8
XFILLER_18_141 VPWR VGND sg13cmos5l_decap_8
XFILLER_18_148 VPWR VGND sg13cmos5l_decap_8
XFILLER_18_155 VPWR VGND sg13cmos5l_decap_8
XFILLER_18_162 VPWR VGND sg13cmos5l_decap_8
XFILLER_18_169 VPWR VGND sg13cmos5l_decap_8
XFILLER_18_176 VPWR VGND sg13cmos5l_decap_8
XFILLER_18_183 VPWR VGND sg13cmos5l_decap_8
XFILLER_19_0 VPWR VGND sg13cmos5l_decap_8
XFILLER_19_7 VPWR VGND sg13cmos5l_decap_8
XFILLER_19_14 VPWR VGND sg13cmos5l_decap_8
XFILLER_19_21 VPWR VGND sg13cmos5l_decap_8
XFILLER_19_28 VPWR VGND sg13cmos5l_decap_8
XFILLER_19_50 VPWR VGND sg13cmos5l_decap_8
XFILLER_19_57 VPWR VGND sg13cmos5l_decap_4
XFILLER_19_74 VPWR VGND sg13cmos5l_decap_8
XFILLER_19_81 VPWR VGND sg13cmos5l_decap_4
XFILLER_19_92 VPWR VGND sg13cmos5l_decap_8
XFILLER_19_123 VPWR VGND sg13cmos5l_decap_8
XFILLER_19_130 VPWR VGND sg13cmos5l_decap_8
XFILLER_19_137 VPWR VGND sg13cmos5l_decap_8
XFILLER_19_144 VPWR VGND sg13cmos5l_decap_8
XFILLER_19_151 VPWR VGND sg13cmos5l_decap_8
XFILLER_19_158 VPWR VGND sg13cmos5l_decap_8
XFILLER_19_165 VPWR VGND sg13cmos5l_decap_8
XFILLER_19_172 VPWR VGND sg13cmos5l_decap_8
XFILLER_19_179 VPWR VGND sg13cmos5l_decap_8
XFILLER_19_186 VPWR VGND sg13cmos5l_decap_4
XFILLER_20_0 VPWR VGND sg13cmos5l_decap_8
XFILLER_20_7 VPWR VGND sg13cmos5l_decap_8
XFILLER_20_14 VPWR VGND sg13cmos5l_decap_8
XFILLER_20_50 VPWR VGND sg13cmos5l_decap_8
XFILLER_20_92 VPWR VGND sg13cmos5l_decap_8
XFILLER_20_134 VPWR VGND sg13cmos5l_decap_8
XFILLER_20_141 VPWR VGND sg13cmos5l_decap_8
XFILLER_20_148 VPWR VGND sg13cmos5l_decap_8
XFILLER_20_155 VPWR VGND sg13cmos5l_decap_8
XFILLER_20_162 VPWR VGND sg13cmos5l_decap_8
XFILLER_20_169 VPWR VGND sg13cmos5l_decap_8
XFILLER_20_176 VPWR VGND sg13cmos5l_decap_8
XFILLER_20_183 VPWR VGND sg13cmos5l_decap_8
XFILLER_21_0 VPWR VGND sg13cmos5l_decap_8
XFILLER_21_7 VPWR VGND sg13cmos5l_decap_8
XFILLER_21_14 VPWR VGND sg13cmos5l_decap_8
XFILLER_21_50 VPWR VGND sg13cmos5l_decap_8
XFILLER_21_92 VPWR VGND sg13cmos5l_decap_8
XFILLER_21_127 VPWR VGND sg13cmos5l_decap_8
XFILLER_21_134 VPWR VGND sg13cmos5l_decap_8
XFILLER_21_141 VPWR VGND sg13cmos5l_decap_8
XFILLER_21_148 VPWR VGND sg13cmos5l_decap_8
XFILLER_21_155 VPWR VGND sg13cmos5l_decap_8
XFILLER_21_162 VPWR VGND sg13cmos5l_decap_8
XFILLER_21_173 VPWR VGND sg13cmos5l_decap_8
XFILLER_21_180 VPWR VGND sg13cmos5l_decap_8
XFILLER_21_187 VPWR VGND sg13cmos5l_decap_4
XFILLER_22_0 VPWR VGND sg13cmos5l_decap_8
XFILLER_22_7 VPWR VGND sg13cmos5l_decap_8
XFILLER_22_46 VPWR VGND sg13cmos5l_decap_8
XFILLER_22_53 VPWR VGND sg13cmos5l_decap_8
XFILLER_22_90 VPWR VGND sg13cmos5l_decap_8
XFILLER_22_109 VPWR VGND sg13cmos5l_decap_8
XFILLER_22_116 VPWR VGND sg13cmos5l_decap_4
XFILLER_22_124 VPWR VGND sg13cmos5l_decap_8
XFILLER_22_131 VPWR VGND sg13cmos5l_decap_8
XFILLER_22_138 VPWR VGND sg13cmos5l_decap_8
XFILLER_22_145 VPWR VGND sg13cmos5l_decap_8
XFILLER_22_152 VPWR VGND sg13cmos5l_decap_8
XFILLER_22_159 VPWR VGND sg13cmos5l_decap_8
XFILLER_22_166 VPWR VGND sg13cmos5l_decap_8
XFILLER_22_173 VPWR VGND sg13cmos5l_decap_8
XFILLER_22_180 VPWR VGND sg13cmos5l_decap_8
XFILLER_22_187 VPWR VGND sg13cmos5l_decap_4
XFILLER_23_0 VPWR VGND sg13cmos5l_decap_8
XFILLER_23_7 VPWR VGND sg13cmos5l_decap_8
XFILLER_23_14 VPWR VGND sg13cmos5l_decap_8
XFILLER_23_21 VPWR VGND sg13cmos5l_decap_4
XFILLER_23_43 VPWR VGND sg13cmos5l_decap_8
XFILLER_23_50 VPWR VGND sg13cmos5l_decap_8
XFILLER_23_57 VPWR VGND sg13cmos5l_decap_8
XFILLER_23_64 VPWR VGND sg13cmos5l_decap_8
XFILLER_23_71 VPWR VGND sg13cmos5l_decap_8
XFILLER_23_78 VPWR VGND sg13cmos5l_decap_8
XFILLER_23_85 VPWR VGND sg13cmos5l_decap_4
XFILLER_23_92 VPWR VGND sg13cmos5l_decap_8
XFILLER_23_104 VPWR VGND sg13cmos5l_decap_8
XFILLER_23_111 VPWR VGND sg13cmos5l_decap_8
XFILLER_23_118 VPWR VGND sg13cmos5l_decap_8
XFILLER_23_129 VPWR VGND sg13cmos5l_decap_8
XFILLER_23_136 VPWR VGND sg13cmos5l_decap_8
XFILLER_23_143 VPWR VGND sg13cmos5l_decap_8
XFILLER_23_150 VPWR VGND sg13cmos5l_decap_4
XFILLER_23_159 VPWR VGND sg13cmos5l_decap_8
XFILLER_23_166 VPWR VGND sg13cmos5l_decap_8
XFILLER_23_173 VPWR VGND sg13cmos5l_decap_8
XFILLER_23_180 VPWR VGND sg13cmos5l_decap_4
.ENDS tdc

* ===== build/sg13cmos5l/macros/bbpd/cdl/bbpd.cdl
* CDL Netlist generated by OpenROAD

*.BUSDELIMITER [

.SUBCKT bbpd C[0] C[1] C[2] C[3] C[4] C[5] C[6] C[7] clk_ref  comp div load resetb seed[0] seed[1] seed[2] seed[3] seed[4]  seed[5] seed[6] seed[7] VPWR VGND
Xx1.x1 x1.comp_raw div clk_ref net24 VPWR VGND sg13cmos5l_dfrbpq_1
Xx1.x10 clk_dlf x1.net2 VPWR VGND sg13cmos5l_buf_4
Xx1.x2 net19 x1.clk_x2 x1.comp_raw net24 VPWR VGND sg13cmos5l_dfrbpq_2
Xx1.x6 clk_ref_d clk_ref VPWR VGND sg13cmos5l_buf_2
Xx1.x7 x1.clk_x2 clk_ref_d VPWR VGND sg13cmos5l_dlygate4sd3_1
Xx1.x8 x1.net1 x1.clk_x2 VPWR VGND sg13cmos5l_dlygate4sd3_1
Xx1.x9 x1.net2 x1.net1 VPWR VGND sg13cmos5l_dlygate4sd3_1
Xx2._043_ x2._009_ x2.g_bit\[4\].u_xor.y VPWR VGND sg13cmos5l_inv_1
Xx2._044_ x2._008_ net6 VPWR VGND sg13cmos5l_inv_1
Xx2._045_ x2._007_ net7 VPWR VGND sg13cmos5l_inv_1
Xx2._046_ x2._006_ net1 VPWR VGND sg13cmos5l_inv_1
Xx2._047_ x2._005_ x2.g_bit\[2\].u_xor.y VPWR VGND sg13cmos5l_inv_1
Xx2._048_ x2._011_ net20 VPWR VGND sg13cmos5l_inv_1
Xx2._049_ x2.g\[2\] x2._000_ VPWR VGND sg13cmos5l_inv_1
Xx2._050_ x2.load_q x2._001_ VPWR VGND sg13cmos5l_inv_1
Xx2._051_ x2.g\[4\] x2._004_ VPWR VGND sg13cmos5l_inv_1
Xx2._052_ x2._012_ x2.g\[6\] net20 VPWR VGND sg13cmos5l_xnor2_1
Xx2._053_ x2._013_ x2.g\[5\] x2._012_ VPWR VGND sg13cmos5l_xnor2_1
Xx2._054_ x2._014_ x2._004_ x2._013_ VPWR VGND sg13cmos5l_nand2_1
Xx2._055_ x2._015_ x2._004_ x2._013_ VPWR VGND sg13cmos5l_xnor2_1
Xx2._056_ x2._016_ x2.g\[3\] x2._015_ VPWR VGND sg13cmos5l_nor2_1
Xx2._057_ x2._017_ x2.g\[3\] x2._015_ VPWR VGND sg13cmos5l_xor2_1
Xx2._058_ x2._018_ x2.g\[2\] x2._017_ VPWR VGND sg13cmos5l_xnor2_1
Xx2._059_ x2._019_ x2.g\[1\] x2.g\[0\] VPWR VGND sg13cmos5l_nor2_1
Xx2._060_ x2._020_ x2._000_ x2._016_ x2._019_ VPWR VGND sg13cmos5l_nand3_1
Xx2._061_ x2._021_ x2.g\[5\] x2._000_ x2._016_ x2._019_ VPWR  VGND sg13cmos5l_nand4_1
Xx2._062_ x2._022_ x2.g\[6\] x2._021_ VPWR VGND sg13cmos5l_nand2_1
Xx2._063_ x2.gd\[6\] x2._011_ x2._021_ x2._022_ VPWR VGND  sg13cmos5l_o21ai_1
Xx2._064_ x2._023_ x2._000_ x2._012_ x2._016_ x2._019_ VPWR  VGND sg13cmos5l_nand4_1
Xx2._065_ x2._024_ x2.g\[5\] x2._020_ VPWR VGND sg13cmos5l_nand2b_1
Xx2._066_ x2.gd\[5\] x2._023_ x2._024_ VPWR VGND sg13cmos5l_and2_1
Xx2._067_ x2._025_ x2.g\[3\] x2._018_ x2._019_ VPWR VGND sg13cmos5l_nand3_1
Xx2._068_ x2.gd\[4\] x2._013_ x2.g\[4\] x2._025_ VPWR VGND  sg13cmos5l_mux2_1
Xx2._069_ x2._026_ x2.g\[1\] x2.g\[0\] x2._000_ VPWR VGND  sg13cmos5l_nor3_1
Xx2._070_ x2._027_ x2.g\[3\] x2._026_ VPWR VGND sg13cmos5l_nor2_1
Xx2._071_ x2.gd\[3\] x2.g\[3\] x2._015_ x2._026_ VPWR VGND  sg13cmos5l_mux2_1
Xx2._072_ x2._028_ x2.g\[0\] x2.g\[1\] VPWR VGND sg13cmos5l_nand2b_1
Xx2._073_ x2._029_ x2._017_ x2._028_ VPWR VGND sg13cmos5l_nor2_1
Xx2._074_ x2.gd\[2\] x2._000_ x2._028_ x2._029_ VPWR VGND  sg13cmos5l_a21oi_1
Xx2._075_ x2._030_ x2.g\[0\] x2._018_ VPWR VGND sg13cmos5l_nand2_1
Xx2._076_ x2.gd\[1\] x2.g\[0\] x2._018_ x2._019_ VPWR VGND  sg13cmos5l_a21oi_1
Xx2._077_ x2.gd\[0\] x2.g\[1\] x2._018_ VPWR VGND sg13cmos5l_xnor2_1
Xx2._078_ x2.gu\[0\] x2.gd\[0\] VPWR VGND sg13cmos5l_inv_1
Xx2._079_ x2._031_ x2._000_ x2._017_ x2._019_ VPWR VGND sg13cmos5l_nand3_1
Xx2._080_ x2._032_ x2._014_ x2._031_ VPWR VGND sg13cmos5l_nor2_1
Xx2._081_ x2.gu\[6\] x2.g\[6\] x2._011_ x2._032_ VPWR VGND  sg13cmos5l_mux2_1
Xx2._082_ x2._033_ x2._004_ x2._031_ VPWR VGND sg13cmos5l_nor2_1
Xx2._083_ x2.gu\[5\] x2.g\[5\] x2._012_ x2._033_ VPWR VGND  sg13cmos5l_mux2_1
Xx2._084_ x2._034_ x2._013_ x2._004_ x2._031_ VPWR VGND sg13cmos5l_mux2_1
Xx2._085_ x2.gu\[4\] x2._034_ VPWR VGND sg13cmos5l_inv_1
Xx2._086_ x2.gu\[3\] x2._015_ x2._026_ x2._027_ VPWR VGND  sg13cmos5l_a21oi_1
Xx2._087_ x2.gu\[2\] x2.g\[2\] x2._028_ x2._029_ VPWR VGND  sg13cmos5l_a21o_1
Xx2._088_ x2.gu\[1\] x2._028_ x2._030_ VPWR VGND sg13cmos5l_nand2_1
Xx2._089_ x2.gseed\[5\] x2.seed_q\[5\] x2.seed_q\[6\] VPWR  VGND sg13cmos5l_xor2_1
Xx2._090_ x2.gseed\[4\] x2.seed_q\[5\] x2._002_ VPWR VGND  sg13cmos5l_xnor2_1
Xx2._091_ x2.gseed\[3\] x2._002_ x2._003_ VPWR VGND sg13cmos5l_xor2_1
Xx2._092_ x2.gseed\[2\] x2.seed_q\[2\] x2._003_ VPWR VGND  sg13cmos5l_xnor2_1
Xx2._093_ x2.gseed\[1\] x2.seed_q\[2\] x2.seed_q\[1\] VPWR  VGND sg13cmos5l_xor2_1
Xx2._094_ x2.gseed\[0\] x2.seed_q\[1\] x2.seed_q\[0\] VPWR  VGND sg13cmos5l_xor2_1
Xx2._095_ x2.gseed\[6\] x2.seed_q\[6\] x2.gseed\[7\] VPWR  VGND sg13cmos5l_xor2_1
Xx2._096_ x2._010_ x2.g\[5\] x2._023_ net20 VPWR VGND sg13cmos5l_o21ai_1
Xx2._097_ x2.gd\[7\] x2._010_ VPWR VGND sg13cmos5l_inv_1
Xx2._098_ x2.gu\[7\] x2.g\[6\] x2._032_ net20 VPWR VGND sg13cmos5l_a21o_1
Xx2._099_ x2.g\[0\] clk_dlf x2.g_bit\[0\].u_xor.y net25 VPWR  VGND sg13cmos5l_dfrbpq_1
Xx2._100_ x2.g\[1\] clk_dlf x2.g_bit\[1\].u_xor.y net26 VPWR  VGND sg13cmos5l_dfrbpq_1
Xx2._101_ x2._000_ clk_dlf x2._005_ net26 VPWR VGND sg13cmos5l_dfrbpq_1
Xx2._102_ x2.g\[3\] clk_dlf x2.g_bit\[3\].u_xor.y net25 VPWR  VGND sg13cmos5l_dfrbpq_1
Xx2._103_ x2._004_ clk_dlf x2._009_ net24 VPWR VGND sg13cmos5l_dfrbpq_1
Xx2._104_ x2.g\[5\] clk_dlf x2.g_bit\[5\].u_xor.y net24 VPWR  VGND sg13cmos5l_dfrbpq_1
Xx2._105_ x2.g\[6\] clk_dlf x2.g_bit\[6\].u_xor.y net24 VPWR  VGND sg13cmos5l_dfrbpq_1
Xx2._106_ net18 clk_dlf x2.g_bit\[7\].u_xor.y net26 VPWR VGND  sg13cmos5l_dfrbpq_1
Xx2._107_ x2._001_ clk_ref_d x2._006_ net24 VPWR VGND sg13cmos5l_dfrbpq_1
Xx2._108_ x2.seed_q\[0\] clk_ref_d net3 net25 VPWR VGND sg13cmos5l_dfrbpq_1
Xx2._109_ x2.seed_q\[1\] clk_ref_d net4 net25 VPWR VGND sg13cmos5l_dfrbpq_1
Xx2._110_ x2.seed_q\[2\] clk_ref_d net5 net25 VPWR VGND sg13cmos5l_dfrbpq_1
Xx2._111_ x2._003_ clk_ref_d x2._008_ net25 VPWR VGND sg13cmos5l_dfrbpq_1
Xx2._112_ x2._002_ clk_ref_d x2._007_ net25 VPWR VGND sg13cmos5l_dfrbpq_1
Xx2._113_ x2.seed_q\[5\] clk_ref_d net8 net25 VPWR VGND sg13cmos5l_dfrbpq_1
Xx2._114_ x2.seed_q\[6\] clk_ref_d net9 net24 VPWR VGND sg13cmos5l_dfrbpq_1
Xx2._115_ x2.gseed\[7\] clk_ref_d net10 net24 VPWR VGND sg13cmos5l_dfrbpq_1
Xx2._116_ x2.g\[7\] net20 VPWR VGND sg13cmos5l_buf_1
Xx2._117_ x2.seed_q\[7\] x2.gseed\[7\] VPWR VGND sg13cmos5l_buf_1
Xx2._118_ x2.cd\[0\] net23 x2.diff\[0\] VPWR VGND sg13cmos5l_and2_1
Xx2._119_ x2.g_bit\[0\].u_xor.y x2.g_bit\[0\].u_xor.a x2.cd\[0\]  VPWR VGND sg13cmos5l_xor2_1
Xx2._120_ x2.cd\[1\] net23 x2.diff\[1\] VPWR VGND sg13cmos5l_and2_1
Xx2._121_ x2.g_bit\[1\].u_xor.y x2.g_bit\[1\].u_xor.a x2.cd\[1\]  VPWR VGND sg13cmos5l_xor2_1
Xx2._122_ x2.cd\[2\] net23 x2.diff\[2\] VPWR VGND sg13cmos5l_and2_1
Xx2._123_ x2.g_bit\[2\].u_xor.y x2.g_bit\[2\].u_xor.a x2.cd\[2\]  VPWR VGND sg13cmos5l_xor2_1
Xx2._124_ x2.cd\[3\] net23 x2.diff\[3\] VPWR VGND sg13cmos5l_and2_1
Xx2._125_ x2.g_bit\[3\].u_xor.y x2.g_bit\[3\].u_xor.a x2.cd\[3\]  VPWR VGND sg13cmos5l_xor2_1
Xx2._126_ x2.cd\[4\] net23 x2.diff\[4\] VPWR VGND sg13cmos5l_and2_1
Xx2._127_ x2.g_bit\[4\].u_xor.y x2.g_bit\[4\].u_xor.a x2.cd\[4\]  VPWR VGND sg13cmos5l_xor2_1
Xx2._128_ x2.cd\[5\] net23 x2.diff\[5\] VPWR VGND sg13cmos5l_and2_1
Xx2._129_ x2.g_bit\[5\].u_xor.y x2.g_bit\[5\].u_xor.a x2.cd\[5\]  VPWR VGND sg13cmos5l_xor2_1
Xx2._130_ x2.cd\[6\] net23 x2.diff\[6\] VPWR VGND sg13cmos5l_and2_1
Xx2._131_ x2.g_bit\[6\].u_xor.y x2.g_bit\[6\].u_xor.a x2.cd\[6\]  VPWR VGND sg13cmos5l_xor2_1
Xx2._132_ x2.cd\[7\] net23 x2.diff\[7\] VPWR VGND sg13cmos5l_and2_1
Xx2._133_ x2.g_bit\[7\].u_xor.y x2.g_bit\[7\].u_xor.a x2.cd\[7\]  VPWR VGND sg13cmos5l_xor2_1
Xx2._134_ x2.g_g2b\[0\].l1.u.y x2.g\[0\] x2.g\[1\] VPWR VGND  sg13cmos5l_xor2_1
Xx2._135_ x2.g_g2b\[0\].l2.u.y x2.g_g2b\[0\].l1.u.y x2.g_g2b\[0\].l2.u.b  VPWR VGND sg13cmos5l_xor2_1
Xx2._136_ net11 x2.g_g2b\[0\].l2.u.y net15 VPWR VGND sg13cmos5l_xor2_1
Xx2._137_ x2.g_g2b\[1\].l1.u.y x2.g\[1\] x2.g\[2\] VPWR VGND  sg13cmos5l_xor2_1
Xx2._138_ x2.g_g2b\[1\].l2.u.y x2.g_g2b\[1\].l1.u.y x2.g_g2b\[1\].l2.u.b  VPWR VGND sg13cmos5l_xor2_1
Xx2._139_ net12 x2.g_g2b\[1\].l2.u.y net16 VPWR VGND sg13cmos5l_xor2_1
Xx2._140_ x2.g_g2b\[0\].l2.u.b x2.g\[2\] x2.g\[3\] VPWR VGND  sg13cmos5l_xor2_1
Xx2._141_ x2.g_g2b\[2\].l2.u.y x2.g_g2b\[0\].l2.u.b x2.g_g2b\[2\].l2.u.b  VPWR VGND sg13cmos5l_xor2_1
Xx2._142_ net13 x2.g_g2b\[2\].l2.u.y net17 VPWR VGND sg13cmos5l_xor2_1
Xx2._143_ x2.g_g2b\[1\].l2.u.b x2.g\[3\] x2.g\[4\] VPWR VGND  sg13cmos5l_xor2_1
Xx2._144_ x2.g_g2b\[3\].l2.u.y x2.g_g2b\[1\].l2.u.b x2.g_g2b\[3\].l2.u.b  VPWR VGND sg13cmos5l_xor2_1
Xx2._145_ net14 x2.g_g2b\[3\].l2.u.y net20 VPWR VGND sg13cmos5l_xor2_1
Xx2._146_ x2.g_g2b\[2\].l2.u.b x2.g\[4\] x2.g\[5\] VPWR VGND  sg13cmos5l_xor2_1
Xx2._147_ net15 x2.g_g2b\[2\].l2.u.b net17 VPWR VGND sg13cmos5l_xor2_1
Xx2._148_ x2.g_g2b\[3\].l2.u.b x2.g\[5\] x2.g\[6\] VPWR VGND  sg13cmos5l_xor2_1
Xx2._149_ net16 x2.g_g2b\[3\].l2.u.b net20 VPWR VGND sg13cmos5l_xor2_1
Xx2._150_ net17 x2.g\[6\] net20 VPWR VGND sg13cmos5l_xor2_1
Xx2._151_ x2._035_ x2.gu\[6\] x2.gd\[6\] VPWR VGND sg13cmos5l_xnor2_1
Xx2._152_ x2.diff\[6\] net21 x2._035_ VPWR VGND sg13cmos5l_nor2_1
Xx2._153_ x2._036_ x2.gu\[5\] x2.gd\[5\] VPWR VGND sg13cmos5l_xnor2_1
Xx2._154_ x2.diff\[5\] net21 x2._036_ VPWR VGND sg13cmos5l_nor2_1
Xx2._155_ x2._037_ x2.gu\[4\] x2.gd\[4\] VPWR VGND sg13cmos5l_xnor2_1
Xx2._156_ x2.diff\[4\] net21 x2._037_ VPWR VGND sg13cmos5l_nor2_1
Xx2._157_ x2._038_ x2.gu\[3\] x2.gd\[3\] VPWR VGND sg13cmos5l_xnor2_1
Xx2._158_ x2.diff\[3\] net22 x2._038_ VPWR VGND sg13cmos5l_nor2_1
Xx2._159_ x2._039_ x2.gu\[2\] x2.gd\[2\] VPWR VGND sg13cmos5l_xnor2_1
Xx2._160_ x2.diff\[2\] net22 x2._039_ VPWR VGND sg13cmos5l_nor2_1
Xx2._161_ x2._040_ x2.gu\[1\] x2.gd\[1\] VPWR VGND sg13cmos5l_xnor2_1
Xx2._162_ x2.diff\[1\] net22 x2._040_ VPWR VGND sg13cmos5l_nor2_1
Xx2._163_ x2._041_ x2.gu\[0\] x2.gd\[0\] VPWR VGND sg13cmos5l_xnor2_1
Xx2._164_ x2.diff\[0\] net22 x2._041_ VPWR VGND sg13cmos5l_nor2_1
Xx2._165_ x2.g_bit\[6\].u_xor.a x2.gu\[6\] x2.gseed\[6\] net21  VPWR VGND sg13cmos5l_mux2_1
Xx2._166_ x2.g_bit\[5\].u_xor.a x2.gu\[5\] x2.gseed\[5\] net21  VPWR VGND sg13cmos5l_mux2_1
Xx2._167_ x2.g_bit\[4\].u_xor.a x2.gu\[4\] x2.gseed\[4\] net21  VPWR VGND sg13cmos5l_mux2_1
Xx2._168_ x2.g_bit\[3\].u_xor.a x2.gu\[3\] x2.gseed\[3\] net22  VPWR VGND sg13cmos5l_mux2_1
Xx2._169_ x2.g_bit\[2\].u_xor.a x2.gu\[2\] x2.gseed\[2\] net22  VPWR VGND sg13cmos5l_mux2_1
Xx2._170_ x2.g_bit\[1\].u_xor.a x2.gu\[1\] x2.gseed\[1\] net22  VPWR VGND sg13cmos5l_mux2_1
Xx2._171_ x2.g_bit\[0\].u_xor.a x2.gu\[0\] x2.gseed\[0\] net22  VPWR VGND sg13cmos5l_mux2_1
Xx2._172_ x2._042_ x2.gu\[7\] x2.gd\[7\] VPWR VGND sg13cmos5l_xnor2_1
Xx2._173_ x2.diff\[7\] net21 x2._042_ VPWR VGND sg13cmos5l_nor2_1
Xx2._174_ x2.g_bit\[7\].u_xor.a x2.gu\[7\] x2.gseed\[7\] net21  VPWR VGND sg13cmos5l_mux2_1
Xinput1 net1 load VPWR VGND sg13cmos5l_buf_1
Xinput2 net2 resetb VPWR VGND sg13cmos5l_buf_1
Xinput3 net3 seed[0] VPWR VGND sg13cmos5l_buf_1
Xinput4 net4 seed[1] VPWR VGND sg13cmos5l_buf_1
Xinput5 net5 seed[2] VPWR VGND sg13cmos5l_buf_1
Xinput6 net6 seed[3] VPWR VGND sg13cmos5l_buf_1
Xinput7 net7 seed[4] VPWR VGND sg13cmos5l_buf_1
Xinput8 net8 seed[5] VPWR VGND sg13cmos5l_buf_1
Xinput9 net9 seed[6] VPWR VGND sg13cmos5l_buf_1
Xinput10 net10 seed[7] VPWR VGND sg13cmos5l_buf_1
Xoutput11 C[0] net11 VPWR VGND sg13cmos5l_buf_1
Xoutput12 C[1] net12 VPWR VGND sg13cmos5l_buf_1
Xoutput13 C[2] net13 VPWR VGND sg13cmos5l_buf_1
Xoutput14 C[3] net14 VPWR VGND sg13cmos5l_buf_1
Xoutput15 C[4] net15 VPWR VGND sg13cmos5l_buf_1
Xoutput16 C[5] net16 VPWR VGND sg13cmos5l_buf_1
Xoutput17 C[6] net17 VPWR VGND sg13cmos5l_buf_1
Xoutput18 C[7] net18 VPWR VGND sg13cmos5l_buf_1
Xoutput19 comp net19 VPWR VGND sg13cmos5l_buf_1
Xfanout20 net20 net18 VPWR VGND sg13cmos5l_buf_1
Xfanout21 net21 x2.load_q VPWR VGND sg13cmos5l_buf_1
Xfanout22 net22 x2.load_q VPWR VGND sg13cmos5l_buf_1
Xfanout23 net23 net19 VPWR VGND sg13cmos5l_buf_2
Xfanout24 net24 net26 VPWR VGND sg13cmos5l_buf_1
Xfanout25 net25 net26 VPWR VGND sg13cmos5l_buf_1
Xfanout26 net26 net2 VPWR VGND sg13cmos5l_buf_1
XFILLER_0_0 VPWR VGND sg13cmos5l_decap_8
XFILLER_0_7 VPWR VGND sg13cmos5l_decap_8
XFILLER_0_49 VPWR VGND sg13cmos5l_decap_8
XFILLER_0_92 VPWR VGND sg13cmos5l_decap_8
XFILLER_0_104 VPWR VGND sg13cmos5l_decap_4
XFILLER_0_118 VPWR VGND sg13cmos5l_decap_8
XFILLER_0_129 VPWR VGND sg13cmos5l_decap_8
XFILLER_0_136 VPWR VGND sg13cmos5l_decap_4
XFILLER_0_146 VPWR VGND sg13cmos5l_decap_8
XFILLER_0_153 VPWR VGND sg13cmos5l_decap_4
XFILLER_0_161 VPWR VGND sg13cmos5l_decap_4
XFILLER_1_0 VPWR VGND sg13cmos5l_decap_8
XFILLER_1_7 VPWR VGND sg13cmos5l_decap_8
XFILLER_1_50 VPWR VGND sg13cmos5l_decap_8
XFILLER_1_57 VPWR VGND sg13cmos5l_decap_4
XFILLER_1_92 VPWR VGND sg13cmos5l_decap_8
XFILLER_1_103 VPWR VGND sg13cmos5l_decap_4
XFILLER_1_134 VPWR VGND sg13cmos5l_decap_8
XFILLER_2_0 VPWR VGND sg13cmos5l_decap_8
XFILLER_2_7 VPWR VGND sg13cmos5l_decap_8
XFILLER_2_14 VPWR VGND sg13cmos5l_decap_8
XFILLER_2_21 VPWR VGND sg13cmos5l_decap_4
XFILLER_2_38 VPWR VGND sg13cmos5l_decap_4
XFILLER_2_47 VPWR VGND sg13cmos5l_decap_8
XFILLER_2_54 VPWR VGND sg13cmos5l_decap_4
XFILLER_2_90 VPWR VGND sg13cmos5l_decap_8
XFILLER_2_127 VPWR VGND sg13cmos5l_decap_8
XFILLER_2_134 VPWR VGND sg13cmos5l_decap_8
XFILLER_3_0 VPWR VGND sg13cmos5l_decap_8
XFILLER_3_7 VPWR VGND sg13cmos5l_decap_8
XFILLER_3_26 VPWR VGND sg13cmos5l_decap_8
XFILLER_3_33 VPWR VGND sg13cmos5l_decap_4
XFILLER_3_49 VPWR VGND sg13cmos5l_decap_8
XFILLER_3_67 VPWR VGND sg13cmos5l_decap_4
XFILLER_3_74 VPWR VGND sg13cmos5l_decap_8
XFILLER_3_92 VPWR VGND sg13cmos5l_decap_8
XFILLER_3_99 VPWR VGND sg13cmos5l_decap_8
XFILLER_3_106 VPWR VGND sg13cmos5l_decap_4
XFILLER_3_118 VPWR VGND sg13cmos5l_decap_8
XFILLER_3_134 VPWR VGND sg13cmos5l_decap_8
XFILLER_4_0 VPWR VGND sg13cmos5l_decap_8
XFILLER_4_7 VPWR VGND sg13cmos5l_decap_8
XFILLER_4_45 VPWR VGND sg13cmos5l_decap_8
XFILLER_4_52 VPWR VGND sg13cmos5l_decap_8
XFILLER_4_59 VPWR VGND sg13cmos5l_decap_8
XFILLER_4_66 VPWR VGND sg13cmos5l_decap_8
XFILLER_4_73 VPWR VGND sg13cmos5l_decap_4
XFILLER_4_87 VPWR VGND sg13cmos5l_decap_8
XFILLER_4_94 VPWR VGND sg13cmos5l_decap_8
XFILLER_4_101 VPWR VGND sg13cmos5l_decap_8
XFILLER_4_108 VPWR VGND sg13cmos5l_decap_8
XFILLER_4_115 VPWR VGND sg13cmos5l_decap_8
XFILLER_4_122 VPWR VGND sg13cmos5l_decap_8
XFILLER_4_129 VPWR VGND sg13cmos5l_decap_8
XFILLER_4_136 VPWR VGND sg13cmos5l_decap_8
XFILLER_4_159 VPWR VGND sg13cmos5l_decap_8
XFILLER_4_166 VPWR VGND sg13cmos5l_decap_4
XFILLER_5_0 VPWR VGND sg13cmos5l_decap_8
XFILLER_5_7 VPWR VGND sg13cmos5l_decap_8
XFILLER_5_14 VPWR VGND sg13cmos5l_decap_4
XFILLER_5_29 VPWR VGND sg13cmos5l_decap_8
XFILLER_5_36 VPWR VGND sg13cmos5l_decap_8
XFILLER_5_43 VPWR VGND sg13cmos5l_decap_8
XFILLER_5_50 VPWR VGND sg13cmos5l_decap_8
XFILLER_5_57 VPWR VGND sg13cmos5l_decap_8
XFILLER_5_89 VPWR VGND sg13cmos5l_decap_8
XFILLER_5_96 VPWR VGND sg13cmos5l_decap_4
XFILLER_5_114 VPWR VGND sg13cmos5l_decap_8
XFILLER_5_121 VPWR VGND sg13cmos5l_decap_8
XFILLER_5_128 VPWR VGND sg13cmos5l_decap_8
XFILLER_5_135 VPWR VGND sg13cmos5l_decap_8
XFILLER_5_142 VPWR VGND sg13cmos5l_decap_8
XFILLER_5_149 VPWR VGND sg13cmos5l_decap_8
XFILLER_5_156 VPWR VGND sg13cmos5l_decap_8
XFILLER_5_163 VPWR VGND sg13cmos5l_decap_8
XFILLER_6_0 VPWR VGND sg13cmos5l_decap_8
XFILLER_6_7 VPWR VGND sg13cmos5l_decap_8
XFILLER_6_34 VPWR VGND sg13cmos5l_decap_4
XFILLER_6_44 VPWR VGND sg13cmos5l_decap_8
XFILLER_6_51 VPWR VGND sg13cmos5l_decap_8
XFILLER_6_86 VPWR VGND sg13cmos5l_decap_8
XFILLER_6_93 VPWR VGND sg13cmos5l_decap_8
XFILLER_6_125 VPWR VGND sg13cmos5l_decap_8
XFILLER_6_132 VPWR VGND sg13cmos5l_decap_8
XFILLER_6_150 VPWR VGND sg13cmos5l_decap_8
XFILLER_6_157 VPWR VGND sg13cmos5l_decap_8
XFILLER_6_164 VPWR VGND sg13cmos5l_decap_4
XFILLER_7_0 VPWR VGND sg13cmos5l_decap_8
XFILLER_7_7 VPWR VGND sg13cmos5l_decap_8
XFILLER_7_14 VPWR VGND sg13cmos5l_decap_8
XFILLER_7_21 VPWR VGND sg13cmos5l_decap_8
XFILLER_7_50 VPWR VGND sg13cmos5l_decap_8
XFILLER_7_57 VPWR VGND sg13cmos5l_decap_8
XFILLER_7_64 VPWR VGND sg13cmos5l_decap_4
XFILLER_7_71 VPWR VGND sg13cmos5l_decap_4
XFILLER_7_88 VPWR VGND sg13cmos5l_decap_8
XFILLER_7_95 VPWR VGND sg13cmos5l_decap_8
XFILLER_7_131 VPWR VGND sg13cmos5l_decap_8
XFILLER_7_138 VPWR VGND sg13cmos5l_decap_4
XFILLER_7_161 VPWR VGND sg13cmos5l_decap_8
XFILLER_8_0 VPWR VGND sg13cmos5l_decap_8
XFILLER_8_7 VPWR VGND sg13cmos5l_decap_8
XFILLER_8_14 VPWR VGND sg13cmos5l_decap_8
XFILLER_8_50 VPWR VGND sg13cmos5l_decap_8
XFILLER_8_57 VPWR VGND sg13cmos5l_decap_8
XFILLER_8_64 VPWR VGND sg13cmos5l_decap_8
XFILLER_8_71 VPWR VGND sg13cmos5l_decap_8
XFILLER_8_78 VPWR VGND sg13cmos5l_decap_8
XFILLER_8_85 VPWR VGND sg13cmos5l_decap_8
XFILLER_8_92 VPWR VGND sg13cmos5l_decap_8
XFILLER_8_115 VPWR VGND sg13cmos5l_decap_8
XFILLER_8_122 VPWR VGND sg13cmos5l_decap_8
XFILLER_8_134 VPWR VGND sg13cmos5l_decap_8
XFILLER_8_150 VPWR VGND sg13cmos5l_decap_8
XFILLER_8_157 VPWR VGND sg13cmos5l_decap_8
XFILLER_8_164 VPWR VGND sg13cmos5l_decap_4
XFILLER_9_0 VPWR VGND sg13cmos5l_decap_8
XFILLER_9_7 VPWR VGND sg13cmos5l_decap_8
XFILLER_9_14 VPWR VGND sg13cmos5l_decap_8
XFILLER_9_21 VPWR VGND sg13cmos5l_decap_8
XFILLER_9_50 VPWR VGND sg13cmos5l_decap_8
XFILLER_9_91 VPWR VGND sg13cmos5l_decap_8
XFILLER_9_98 VPWR VGND sg13cmos5l_decap_4
XFILLER_9_108 VPWR VGND sg13cmos5l_decap_8
XFILLER_9_115 VPWR VGND sg13cmos5l_decap_8
XFILLER_9_122 VPWR VGND sg13cmos5l_decap_8
XFILLER_9_129 VPWR VGND sg13cmos5l_decap_8
XFILLER_9_136 VPWR VGND sg13cmos5l_decap_4
XFILLER_10_0 VPWR VGND sg13cmos5l_decap_8
XFILLER_10_7 VPWR VGND sg13cmos5l_decap_8
XFILLER_10_14 VPWR VGND sg13cmos5l_decap_8
XFILLER_10_27 VPWR VGND sg13cmos5l_decap_8
XFILLER_10_34 VPWR VGND sg13cmos5l_decap_8
XFILLER_10_41 VPWR VGND sg13cmos5l_decap_8
XFILLER_10_48 VPWR VGND sg13cmos5l_decap_8
XFILLER_10_55 VPWR VGND sg13cmos5l_decap_8
XFILLER_10_89 VPWR VGND sg13cmos5l_decap_8
XFILLER_10_96 VPWR VGND sg13cmos5l_decap_8
XFILLER_10_103 VPWR VGND sg13cmos5l_decap_8
XFILLER_10_110 VPWR VGND sg13cmos5l_decap_8
XFILLER_10_117 VPWR VGND sg13cmos5l_decap_8
XFILLER_10_134 VPWR VGND sg13cmos5l_decap_8
XFILLER_10_150 VPWR VGND sg13cmos5l_decap_8
XFILLER_10_157 VPWR VGND sg13cmos5l_decap_8
XFILLER_10_164 VPWR VGND sg13cmos5l_decap_4
XFILLER_11_0 VPWR VGND sg13cmos5l_decap_8
XFILLER_11_7 VPWR VGND sg13cmos5l_decap_8
XFILLER_11_50 VPWR VGND sg13cmos5l_decap_8
XFILLER_11_70 VPWR VGND sg13cmos5l_decap_8
XFILLER_11_82 VPWR VGND sg13cmos5l_decap_4
XFILLER_11_92 VPWR VGND sg13cmos5l_decap_8
XFILLER_11_99 VPWR VGND sg13cmos5l_decap_4
XFILLER_11_110 VPWR VGND sg13cmos5l_decap_8
XFILLER_11_134 VPWR VGND sg13cmos5l_decap_8
XFILLER_11_152 VPWR VGND sg13cmos5l_decap_8
XFILLER_11_159 VPWR VGND sg13cmos5l_decap_8
XFILLER_11_166 VPWR VGND sg13cmos5l_decap_4
XFILLER_12_9 VPWR VGND sg13cmos5l_decap_8
XFILLER_12_50 VPWR VGND sg13cmos5l_decap_8
XFILLER_12_57 VPWR VGND sg13cmos5l_decap_4
XFILLER_12_92 VPWR VGND sg13cmos5l_decap_8
XFILLER_12_99 VPWR VGND sg13cmos5l_decap_4
XFILLER_12_109 VPWR VGND sg13cmos5l_decap_4
XFILLER_12_132 VPWR VGND sg13cmos5l_decap_8
XFILLER_13_0 VPWR VGND sg13cmos5l_decap_8
XFILLER_13_7 VPWR VGND sg13cmos5l_decap_8
XFILLER_13_14 VPWR VGND sg13cmos5l_decap_4
XFILLER_13_50 VPWR VGND sg13cmos5l_decap_8
XFILLER_13_79 VPWR VGND sg13cmos5l_decap_8
XFILLER_13_86 VPWR VGND sg13cmos5l_decap_8
XFILLER_13_93 VPWR VGND sg13cmos5l_decap_8
XFILLER_13_118 VPWR VGND sg13cmos5l_decap_8
XFILLER_13_134 VPWR VGND sg13cmos5l_decap_8
XFILLER_13_145 VPWR VGND sg13cmos5l_decap_8
XFILLER_13_152 VPWR VGND sg13cmos5l_decap_8
XFILLER_13_159 VPWR VGND sg13cmos5l_decap_8
XFILLER_13_166 VPWR VGND sg13cmos5l_decap_4
XFILLER_14_0 VPWR VGND sg13cmos5l_decap_8
XFILLER_14_7 VPWR VGND sg13cmos5l_decap_8
XFILLER_14_50 VPWR VGND sg13cmos5l_decap_8
XFILLER_14_63 VPWR VGND sg13cmos5l_decap_8
XFILLER_14_70 VPWR VGND sg13cmos5l_decap_8
XFILLER_14_77 VPWR VGND sg13cmos5l_decap_8
XFILLER_14_84 VPWR VGND sg13cmos5l_decap_8
XFILLER_14_91 VPWR VGND sg13cmos5l_decap_8
XFILLER_14_104 VPWR VGND sg13cmos5l_decap_4
XFILLER_14_134 VPWR VGND sg13cmos5l_decap_8
XFILLER_15_0 VPWR VGND sg13cmos5l_decap_8
XFILLER_15_7 VPWR VGND sg13cmos5l_decap_8
XFILLER_15_14 VPWR VGND sg13cmos5l_decap_4
XFILLER_15_50 VPWR VGND sg13cmos5l_decap_8
XFILLER_15_57 VPWR VGND sg13cmos5l_decap_8
XFILLER_15_64 VPWR VGND sg13cmos5l_decap_8
XFILLER_15_71 VPWR VGND sg13cmos5l_decap_8
XFILLER_15_78 VPWR VGND sg13cmos5l_decap_8
XFILLER_15_85 VPWR VGND sg13cmos5l_decap_8
XFILLER_15_92 VPWR VGND sg13cmos5l_decap_8
XFILLER_15_99 VPWR VGND sg13cmos5l_decap_8
XFILLER_15_106 VPWR VGND sg13cmos5l_decap_8
XFILLER_15_120 VPWR VGND sg13cmos5l_decap_4
XFILLER_15_134 VPWR VGND sg13cmos5l_decap_8
XFILLER_15_141 VPWR VGND sg13cmos5l_decap_8
XFILLER_15_148 VPWR VGND sg13cmos5l_decap_8
XFILLER_15_155 VPWR VGND sg13cmos5l_decap_8
XFILLER_15_162 VPWR VGND sg13cmos5l_decap_8
XFILLER_16_0 VPWR VGND sg13cmos5l_decap_8
XFILLER_16_7 VPWR VGND sg13cmos5l_decap_8
XFILLER_16_14 VPWR VGND sg13cmos5l_decap_8
XFILLER_16_21 VPWR VGND sg13cmos5l_decap_8
XFILLER_16_28 VPWR VGND sg13cmos5l_decap_8
XFILLER_16_35 VPWR VGND sg13cmos5l_decap_8
XFILLER_16_42 VPWR VGND sg13cmos5l_decap_8
XFILLER_16_49 VPWR VGND sg13cmos5l_decap_8
XFILLER_16_56 VPWR VGND sg13cmos5l_decap_8
XFILLER_16_63 VPWR VGND sg13cmos5l_decap_8
XFILLER_16_70 VPWR VGND sg13cmos5l_decap_8
XFILLER_16_77 VPWR VGND sg13cmos5l_decap_8
XFILLER_16_92 VPWR VGND sg13cmos5l_decap_8
XFILLER_16_110 VPWR VGND sg13cmos5l_decap_8
XFILLER_16_117 VPWR VGND sg13cmos5l_decap_8
XFILLER_16_124 VPWR VGND sg13cmos5l_decap_8
XFILLER_16_131 VPWR VGND sg13cmos5l_decap_8
XFILLER_16_138 VPWR VGND sg13cmos5l_decap_8
XFILLER_16_145 VPWR VGND sg13cmos5l_decap_8
XFILLER_16_152 VPWR VGND sg13cmos5l_decap_8
XFILLER_16_159 VPWR VGND sg13cmos5l_decap_8
XFILLER_16_166 VPWR VGND sg13cmos5l_decap_4
XFILLER_17_0 VPWR VGND sg13cmos5l_decap_8
XFILLER_17_7 VPWR VGND sg13cmos5l_decap_8
XFILLER_17_14 VPWR VGND sg13cmos5l_decap_8
XFILLER_17_21 VPWR VGND sg13cmos5l_decap_8
XFILLER_17_28 VPWR VGND sg13cmos5l_decap_8
XFILLER_17_35 VPWR VGND sg13cmos5l_decap_8
XFILLER_17_42 VPWR VGND sg13cmos5l_decap_8
XFILLER_17_49 VPWR VGND sg13cmos5l_decap_8
XFILLER_17_56 VPWR VGND sg13cmos5l_decap_8
XFILLER_17_63 VPWR VGND sg13cmos5l_decap_8
XFILLER_17_86 VPWR VGND sg13cmos5l_decap_8
XFILLER_17_93 VPWR VGND sg13cmos5l_decap_8
XFILLER_17_108 VPWR VGND sg13cmos5l_decap_8
XFILLER_17_115 VPWR VGND sg13cmos5l_decap_8
XFILLER_17_122 VPWR VGND sg13cmos5l_decap_8
XFILLER_17_129 VPWR VGND sg13cmos5l_decap_8
XFILLER_17_136 VPWR VGND sg13cmos5l_decap_8
XFILLER_17_143 VPWR VGND sg13cmos5l_decap_8
XFILLER_17_150 VPWR VGND sg13cmos5l_decap_8
XFILLER_17_157 VPWR VGND sg13cmos5l_decap_8
XFILLER_17_164 VPWR VGND sg13cmos5l_decap_4
XFILLER_18_0 VPWR VGND sg13cmos5l_decap_8
XFILLER_18_7 VPWR VGND sg13cmos5l_decap_8
XFILLER_18_14 VPWR VGND sg13cmos5l_decap_8
XFILLER_18_21 VPWR VGND sg13cmos5l_decap_8
XFILLER_18_28 VPWR VGND sg13cmos5l_decap_8
XFILLER_18_35 VPWR VGND sg13cmos5l_decap_8
XFILLER_18_50 VPWR VGND sg13cmos5l_decap_8
XFILLER_18_78 VPWR VGND sg13cmos5l_decap_4
XFILLER_18_90 VPWR VGND sg13cmos5l_decap_8
XFILLER_18_97 VPWR VGND sg13cmos5l_decap_4
XFILLER_18_110 VPWR VGND sg13cmos5l_decap_8
XFILLER_18_117 VPWR VGND sg13cmos5l_decap_8
XFILLER_18_124 VPWR VGND sg13cmos5l_decap_8
XFILLER_18_131 VPWR VGND sg13cmos5l_decap_8
XFILLER_18_138 VPWR VGND sg13cmos5l_decap_8
XFILLER_18_145 VPWR VGND sg13cmos5l_decap_8
XFILLER_18_152 VPWR VGND sg13cmos5l_decap_8
XFILLER_18_159 VPWR VGND sg13cmos5l_decap_8
XFILLER_18_166 VPWR VGND sg13cmos5l_decap_4
XFILLER_19_0 VPWR VGND sg13cmos5l_decap_8
XFILLER_19_7 VPWR VGND sg13cmos5l_decap_8
XFILLER_19_14 VPWR VGND sg13cmos5l_decap_8
XFILLER_19_21 VPWR VGND sg13cmos5l_decap_8
XFILLER_19_28 VPWR VGND sg13cmos5l_decap_8
XFILLER_19_35 VPWR VGND sg13cmos5l_decap_8
XFILLER_19_42 VPWR VGND sg13cmos5l_decap_4
XFILLER_19_50 VPWR VGND sg13cmos5l_decap_8
XFILLER_19_57 VPWR VGND sg13cmos5l_decap_8
XFILLER_19_92 VPWR VGND sg13cmos5l_decap_8
XFILLER_19_116 VPWR VGND sg13cmos5l_decap_8
XFILLER_19_123 VPWR VGND sg13cmos5l_decap_8
XFILLER_19_130 VPWR VGND sg13cmos5l_decap_8
XFILLER_19_137 VPWR VGND sg13cmos5l_decap_8
XFILLER_19_144 VPWR VGND sg13cmos5l_decap_8
XFILLER_19_151 VPWR VGND sg13cmos5l_decap_8
XFILLER_19_158 VPWR VGND sg13cmos5l_decap_8
XFILLER_19_165 VPWR VGND sg13cmos5l_decap_4
XFILLER_20_0 VPWR VGND sg13cmos5l_decap_4
XFILLER_20_9 VPWR VGND sg13cmos5l_decap_8
XFILLER_20_16 VPWR VGND sg13cmos5l_decap_8
XFILLER_20_29 VPWR VGND sg13cmos5l_decap_8
XFILLER_20_36 VPWR VGND sg13cmos5l_decap_8
XFILLER_20_49 VPWR VGND sg13cmos5l_decap_8
XFILLER_20_56 VPWR VGND sg13cmos5l_decap_8
XFILLER_20_69 VPWR VGND sg13cmos5l_decap_8
XFILLER_20_76 VPWR VGND sg13cmos5l_decap_4
XFILLER_20_92 VPWR VGND sg13cmos5l_decap_8
XFILLER_20_99 VPWR VGND sg13cmos5l_decap_4
XFILLER_20_115 VPWR VGND sg13cmos5l_decap_8
XFILLER_20_129 VPWR VGND sg13cmos5l_decap_8
XFILLER_20_136 VPWR VGND sg13cmos5l_decap_8
XFILLER_20_149 VPWR VGND sg13cmos5l_decap_8
XFILLER_20_156 VPWR VGND sg13cmos5l_decap_8
.ENDS bbpd

* ===== build/sg13cmos5l/macros/lock_ctrl/cdl/lock_ctrl.cdl
* CDL Netlist generated by OpenROAD

*.BUSDELIMITER [

.SUBCKT lock_ctrl busy clk code[0] code[1] code[2] code[3]  code[4] code[5] code[6] code[7] hit inj load locked resetb  seed[0] seed[1] seed[2] seed[3] seed[4] seed[5] seed[6] seed[7]  sel start tdc_f[0] tdc_f[1] tdc_f[2] tdc_f[3] tdc_f[4] tdc_f[5]  tdc_f[6] tdc_f[7] tdc_s[0] tdc_s[1] tdc_s[2] tdc_s[3] tdc_s[4]  tdc_s[5] tdc_s[6] tdc_s[7] VPWR VGND
X_373_ net34 net58 VPWR VGND sg13cmos5l_inv_1
X_374_ net35 net59 VPWR VGND sg13cmos5l_inv_1
X_375_ _364_ net16 VPWR VGND sg13cmos5l_inv_1
X_376_ _365_ net17 VPWR VGND sg13cmos5l_inv_1
X_377_ _366_ net19 VPWR VGND sg13cmos5l_inv_1
X_378_ _367_ net20 VPWR VGND sg13cmos5l_inv_1
X_379_ _368_ net8 VPWR VGND sg13cmos5l_inv_1
X_380_ _369_ net9 VPWR VGND sg13cmos5l_inv_1
X_381_ _370_ net44 VPWR VGND sg13cmos5l_inv_1
X_382_ _371_ tmo\[2\] VPWR VGND sg13cmos5l_inv_1
X_383_ _372_ tmo\[3\] VPWR VGND sg13cmos5l_inv_1
X_384_ _031_ miss\[0\] VPWR VGND sg13cmos5l_inv_1
X_385_ _032_ irun\[3\] VPWR VGND sg13cmos5l_inv_1
X_386_ _033_ net10 VPWR VGND sg13cmos5l_inv_1
X_387_ net29 net57 VPWR VGND sg13cmos5l_inv_1
X_388_ _034_ net14 net22 VPWR VGND sg13cmos5l_nand2b_1
X_389_ _035_ net21 net13 VPWR VGND sg13cmos5l_nor2b_1
X_390_ _036_ net14 net22 VPWR VGND sg13cmos5l_xor2_1
X_391_ _037_ _035_ _036_ _034_ VPWR VGND sg13cmos5l_o21ai_1
X_392_ _038_ net15 net23 VPWR VGND sg13cmos5l_nor2b_1
X_393_ _039_ net15 net23 VPWR VGND sg13cmos5l_xnor2_1
X_394_ _040_ _037_ _039_ VPWR VGND sg13cmos5l_xor2_1
X_395_ _041_ _037_ _039_ _038_ VPWR VGND sg13cmos5l_a21oi_1
X_396_ _042_ net24 _364_ VPWR VGND sg13cmos5l_nor2_1
X_397_ _043_ net24 net16 VPWR VGND sg13cmos5l_xor2_1
X_398_ _044_ _041_ _043_ VPWR VGND sg13cmos5l_xnor2_1
X_399_ _045_ net42 net43 VPWR VGND sg13cmos5l_nand2b_1
X_400_ _046_ net17 net25 VPWR VGND sg13cmos5l_nor2b_1
X_401_ _047_ net17 net25 VPWR VGND sg13cmos5l_xor2_1
X_402_ _048_ net24 _364_ _037_ _039_ _038_ VPWR VGND sg13cmos5l_a221oi_1
X_403_ _049_ _042_ _047_ _048_ VPWR VGND sg13cmos5l_nor3_1
X_404_ _050_ _042_ _048_ _047_ VPWR VGND sg13cmos5l_o21ai_1
X_405_ _051_ _049_ _050_ VPWR VGND sg13cmos5l_nor2b_1
X_406_ _052_ _051_ VPWR VGND sg13cmos5l_inv_1
X_407_ _053_ net43 net42 VPWR VGND sg13cmos5l_xnor2_1
X_408_ _054_ _051_ _053_ VPWR VGND sg13cmos5l_nand2_1
X_409_ _055_ _045_ _054_ VPWR VGND sg13cmos5l_nand2_1
X_410_ _056_ _046_ _049_ VPWR VGND sg13cmos5l_nor2_1
X_411_ _057_ net26 net18 VPWR VGND sg13cmos5l_nor2b_1
X_412_ _058_ net26 net18 VPWR VGND sg13cmos5l_nand2b_1
X_413_ _059_ net18 net26 VPWR VGND sg13cmos5l_nor2b_1
X_414_ _060_ net18 net26 VPWR VGND sg13cmos5l_nand2b_1
X_415_ _061_ _058_ _060_ VPWR VGND sg13cmos5l_nand2_1
X_416_ _062_ _056_ _061_ VPWR VGND sg13cmos5l_xor2_1
X_417_ _063_ _056_ _061_ VPWR VGND sg13cmos5l_xnor2_1
X_418_ _064_ net42 _051_ VPWR VGND sg13cmos5l_xnor2_1
X_419_ _065_ _062_ _064_ VPWR VGND sg13cmos5l_nand2_1
X_420_ _066_ _062_ _064_ VPWR VGND sg13cmos5l_xnor2_1
X_421_ _067_ _066_ _055_ VPWR VGND sg13cmos5l_nor2b_1
X_422_ _068_ net19 net27 VPWR VGND sg13cmos5l_xor2_1
X_423_ _069_ _046_ _049_ _058_ VPWR VGND sg13cmos5l_o21ai_1
X_424_ _070_ _046_ _049_ _059_ VPWR VGND sg13cmos5l_nor3_1
X_425_ _071_ _057_ _068_ _070_ VPWR VGND sg13cmos5l_nor3_1
X_426_ _072_ _057_ _068_ _070_ VPWR VGND sg13cmos5l_or3_1
X_427_ _073_ _060_ _068_ _069_ VPWR VGND sg13cmos5l_and3_1
X_428_ _074_ _057_ _070_ _068_ VPWR VGND sg13cmos5l_o21ai_1
X_429_ _075_ _072_ _074_ VPWR VGND sg13cmos5l_nand2_1
X_430_ _076_ _055_ _066_ VPWR VGND sg13cmos5l_xnor2_1
X_431_ _077_ _075_ _076_ VPWR VGND sg13cmos5l_nand2b_1
X_432_ _078_ _067_ _077_ VPWR VGND sg13cmos5l_nand2b_1
X_433_ _079_ net42 _052_ _065_ VPWR VGND sg13cmos5l_o21ai_1
X_434_ _080_ _062_ _075_ VPWR VGND sg13cmos5l_nor2_1
X_435_ _081_ _062_ _075_ VPWR VGND sg13cmos5l_nand2_1
X_436_ _082_ _063_ _071_ _073_ VPWR VGND sg13cmos5l_nor3_1
X_437_ _083_ _062_ _072_ _074_ VPWR VGND sg13cmos5l_nand3_1
X_438_ _084_ _072_ _074_ _062_ VPWR VGND sg13cmos5l_a21oi_1
X_439_ _085_ _071_ _073_ _063_ VPWR VGND sg13cmos5l_o21ai_1
X_440_ _086_ _083_ _085_ VPWR VGND sg13cmos5l_nand2_1
X_441_ _087_ _051_ _083_ _085_ VPWR VGND sg13cmos5l_nand3_1
X_442_ _088_ _082_ _084_ _052_ VPWR VGND sg13cmos5l_o21ai_1
X_443_ _089_ _079_ _087_ _088_ VPWR VGND sg13cmos5l_nand3_1
X_444_ _090_ _087_ _088_ _079_ VPWR VGND sg13cmos5l_a21o_1
X_445_ _091_ _366_ net27 _071_ VPWR VGND sg13cmos5l_a21oi_1
X_446_ _092_ net28 _367_ VPWR VGND sg13cmos5l_nor2_1
X_447_ _093_ net28 _367_ VPWR VGND sg13cmos5l_nand2_1
X_448_ _094_ _092_ _093_ VPWR VGND sg13cmos5l_nor2b_1
X_449_ _095_ _091_ _094_ VPWR VGND sg13cmos5l_xnor2_1
X_450_ _096_ _089_ _090_ _095_ VPWR VGND sg13cmos5l_nand3_1
X_451_ _097_ _089_ _090_ _095_ VPWR VGND sg13cmos5l_a21o_1
X_452_ _098_ _078_ _096_ _097_ VPWR VGND sg13cmos5l_and3_1
X_453_ _099_ _035_ _036_ VPWR VGND sg13cmos5l_xor2_1
X_454_ _100_ net43 _099_ VPWR VGND sg13cmos5l_xor2_1
X_455_ _101_ net42 _100_ VPWR VGND sg13cmos5l_nor2b_1
X_456_ _102_ net43 _099_ _101_ VPWR VGND sg13cmos5l_a21o_1
X_457_ _103_ _051_ _053_ VPWR VGND sg13cmos5l_xor2_1
X_458_ _104_ _102_ _103_ VPWR VGND sg13cmos5l_and2_1
X_459_ _105_ _102_ _103_ VPWR VGND sg13cmos5l_xor2_1
X_460_ _106_ _062_ _105_ _104_ VPWR VGND sg13cmos5l_a21oi_1
X_461_ _107_ _075_ _076_ VPWR VGND sg13cmos5l_xnor2_1
X_462_ _108_ _106_ _107_ VPWR VGND sg13cmos5l_nand2b_1
X_463_ _109_ net21 net13 VPWR VGND sg13cmos5l_xor2_1
X_464_ _110_ _099_ _109_ VPWR VGND sg13cmos5l_and2_1
X_465_ _111_ _099_ _109_ VPWR VGND sg13cmos5l_nand2_1
X_466_ _112_ _036_ _109_ VPWR VGND sg13cmos5l_nor2_1
X_467_ _113_ _099_ _109_ _112_ VPWR VGND sg13cmos5l_a21oi_1
X_468_ _114_ _113_ VPWR VGND sg13cmos5l_inv_1
X_469_ _115_ net43 _113_ VPWR VGND sg13cmos5l_nand2_1
X_470_ _116_ net43 _113_ _110_ VPWR VGND sg13cmos5l_a21oi_1
X_471_ _117_ net42 _100_ VPWR VGND sg13cmos5l_xnor2_1
X_472_ _118_ _116_ _117_ VPWR VGND sg13cmos5l_nand2b_1
X_473_ _119_ _116_ _117_ VPWR VGND sg13cmos5l_xnor2_1
X_474_ _120_ _051_ _119_ VPWR VGND sg13cmos5l_nand2_1
X_475_ _121_ _118_ _120_ VPWR VGND sg13cmos5l_nand2_1
X_476_ _122_ _062_ _105_ VPWR VGND sg13cmos5l_xnor2_1
X_477_ _123_ _122_ _121_ VPWR VGND sg13cmos5l_nor2b_1
X_478_ _124_ _051_ _119_ VPWR VGND sg13cmos5l_xnor2_1
X_479_ _125_ net43 _110_ VPWR VGND sg13cmos5l_and2_1
X_480_ _126_ net43 _110_ VPWR VGND sg13cmos5l_nand2_1
X_481_ _127_ _040_ _113_ VPWR VGND sg13cmos5l_xnor2_1
X_482_ _128_ _111_ _127_ net42 VPWR VGND sg13cmos5l_a21oi_1
X_483_ _129_ _125_ _128_ VPWR VGND sg13cmos5l_nor2_1
X_484_ _130_ _124_ _129_ VPWR VGND sg13cmos5l_nor2_1
X_485_ _131_ _111_ _127_ _125_ VPWR VGND sg13cmos5l_a21o_1
X_486_ _132_ _115_ _131_ net42 VPWR VGND sg13cmos5l_a21oi_1
X_487_ _133_ _044_ _115_ _131_ VPWR VGND sg13cmos5l_and3_1
X_488_ _134_ _126_ _132_ _133_ VPWR VGND sg13cmos5l_or3_1
X_489_ _135_ _045_ _114_ _134_ VPWR VGND sg13cmos5l_o21ai_1
X_490_ _136_ _124_ _129_ VPWR VGND sg13cmos5l_nand2_1
X_491_ _137_ _124_ _129_ VPWR VGND sg13cmos5l_xnor2_1
X_492_ _138_ _135_ _136_ _130_ VPWR VGND sg13cmos5l_a21o_1
X_493_ _139_ _121_ _122_ VPWR VGND sg13cmos5l_xnor2_1
X_494_ _140_ _138_ _139_ _123_ VPWR VGND sg13cmos5l_a21oi_1
X_495_ _141_ _107_ _106_ VPWR VGND sg13cmos5l_nor2b_1
X_496_ _142_ _106_ _107_ VPWR VGND sg13cmos5l_xnor2_1
X_497_ _143_ _140_ _141_ _108_ VPWR VGND sg13cmos5l_o21ai_1
X_498_ _144_ _096_ _097_ _078_ VPWR VGND sg13cmos5l_a21o_1
X_499_ _145_ _098_ _144_ VPWR VGND sg13cmos5l_nor2b_1
X_500_ _146_ _143_ _144_ _098_ VPWR VGND sg13cmos5l_a21oi_1
X_501_ _147_ _089_ _096_ VPWR VGND sg13cmos5l_nand2_1
X_502_ _148_ _086_ _095_ VPWR VGND sg13cmos5l_xnor2_1
X_503_ _149_ _052_ _083_ _084_ VPWR VGND sg13cmos5l_a21oi_1
X_504_ _150_ _148_ _149_ VPWR VGND sg13cmos5l_nand2_1
X_505_ _151_ _148_ _149_ VPWR VGND sg13cmos5l_xnor2_1
X_506_ _152_ _089_ _096_ _151_ VPWR VGND sg13cmos5l_a21oi_1
X_507_ _153_ _147_ _151_ VPWR VGND sg13cmos5l_xor2_1
X_508_ _154_ _146_ _153_ VPWR VGND sg13cmos5l_nor2_1
X_509_ _155_ _146_ _153_ VPWR VGND sg13cmos5l_xor2_1
X_510_ _156_ _138_ _139_ VPWR VGND sg13cmos5l_xnor2_1
X_511_ _157_ _367_ _156_ VPWR VGND sg13cmos5l_nor2_1
X_512_ _158_ _135_ _137_ VPWR VGND sg13cmos5l_xnor2_1
X_513_ _159_ net19 _158_ VPWR VGND sg13cmos5l_nand2_1
X_514_ _160_ _132_ _133_ _126_ VPWR VGND sg13cmos5l_o21ai_1
X_515_ _161_ net18 _134_ _160_ VPWR VGND sg13cmos5l_nand3_1
X_516_ _162_ _134_ _160_ net18 VPWR VGND sg13cmos5l_a21o_1
X_517_ _163_ net16 _113_ VPWR VGND sg13cmos5l_nand2_1
X_518_ _164_ net15 _109_ VPWR VGND sg13cmos5l_nand2_1
X_519_ _165_ net16 _113_ VPWR VGND sg13cmos5l_xnor2_1
X_520_ _166_ _164_ _165_ VPWR VGND sg13cmos5l_or2_1
X_521_ _167_ _365_ _131_ VPWR VGND sg13cmos5l_xnor2_1
X_522_ _168_ _163_ _166_ _167_ VPWR VGND sg13cmos5l_a21o_1
X_523_ _169_ _365_ _131_ _168_ VPWR VGND sg13cmos5l_o21ai_1
X_524_ _170_ _161_ _162_ _169_ VPWR VGND sg13cmos5l_nand3_1
X_525_ _171_ _161_ _170_ VPWR VGND sg13cmos5l_and2_1
X_526_ _172_ net19 _158_ VPWR VGND sg13cmos5l_xnor2_1
X_527_ _173_ _171_ _172_ _159_ VPWR VGND sg13cmos5l_o21ai_1
X_528_ _174_ net20 _156_ VPWR VGND sg13cmos5l_xnor2_1
X_529_ _175_ _173_ _174_ _157_ VPWR VGND sg13cmos5l_a21oi_1
X_530_ _176_ _140_ _142_ VPWR VGND sg13cmos5l_xnor2_1
X_531_ _177_ _175_ _176_ VPWR VGND sg13cmos5l_nor2b_1
X_532_ _178_ _143_ _145_ VPWR VGND sg13cmos5l_xor2_1
X_533_ _179_ _177_ _178_ VPWR VGND sg13cmos5l_nor2_1
X_534_ _180_ _091_ _093_ _092_ VPWR VGND sg13cmos5l_a21o_1
X_535_ _181_ _091_ _093_ _092_ VPWR VGND sg13cmos5l_a21oi_1
X_536_ _182_ _177_ _178_ _180_ VPWR VGND sg13cmos5l_a21oi_1
X_537_ _183_ _179_ _182_ VPWR VGND sg13cmos5l_nor2b_1
X_538_ _184_ _155_ _183_ VPWR VGND sg13cmos5l_nand2_1
X_539_ _185_ _177_ _178_ _155_ VPWR VGND sg13cmos5l_a21o_1
X_540_ _186_ _155_ _177_ _178_ VPWR VGND sg13cmos5l_nand3_1
X_541_ _187_ net41 _185_ _186_ VPWR VGND sg13cmos5l_and3_1
X_542_ _188_ _183_ _187_ VPWR VGND sg13cmos5l_nor2_1
X_543_ _189_ _155_ _183_ _188_ VPWR VGND sg13cmos5l_a21oi_1
X_544_ _190_ _175_ _176_ VPWR VGND sg13cmos5l_xnor2_1
X_545_ _191_ net41 _190_ VPWR VGND sg13cmos5l_and2_1
X_546_ _192_ _183_ _191_ VPWR VGND sg13cmos5l_or2_1
X_547_ _193_ _178_ _191_ VPWR VGND sg13cmos5l_nand2_1
X_548_ _194_ _173_ _174_ VPWR VGND sg13cmos5l_xnor2_1
X_549_ _195_ _180_ _194_ VPWR VGND sg13cmos5l_nor2_1
X_550_ _196_ _190_ _195_ VPWR VGND sg13cmos5l_nor2b_1
X_551_ _197_ _191_ _194_ _196_ VPWR VGND sg13cmos5l_a21o_1
X_552_ _198_ _171_ _172_ VPWR VGND sg13cmos5l_xor2_1
X_553_ _199_ net41 _198_ VPWR VGND sg13cmos5l_and2_1
X_554_ _200_ net41 _198_ VPWR VGND sg13cmos5l_nand2_1
X_555_ _201_ _180_ _194_ _200_ VPWR VGND sg13cmos5l_o21ai_1
X_556_ _202_ _161_ _162_ _169_ VPWR VGND sg13cmos5l_a21o_1
X_557_ _203_ _170_ net41 _202_ VPWR VGND sg13cmos5l_and3_1
X_558_ _204_ _198_ _203_ VPWR VGND sg13cmos5l_nand2_1
X_559_ _205_ _199_ _203_ _204_ VPWR VGND sg13cmos5l_o21ai_1
X_560_ _206_ _163_ _166_ _167_ VPWR VGND sg13cmos5l_nand3_1
X_561_ _207_ _168_ _206_ VPWR VGND sg13cmos5l_and2_1
X_562_ _208_ net41 _207_ VPWR VGND sg13cmos5l_and2_1
X_563_ _209_ _203_ _208_ VPWR VGND sg13cmos5l_nor2_1
X_564_ _210_ _164_ _165_ VPWR VGND sg13cmos5l_xor2_1
X_565_ _211_ net41 _210_ VPWR VGND sg13cmos5l_nand2_1
X_566_ _212_ net41 _207_ _210_ VPWR VGND sg13cmos5l_and3_1
X_567_ _213_ net15 _109_ VPWR VGND sg13cmos5l_xor2_1
X_568_ _214_ net14 _213_ _210_ VPWR VGND sg13cmos5l_a21o_1
X_569_ _215_ net14 net13 _213_ VPWR VGND sg13cmos5l_a21o_1
X_570_ _216_ _181_ _214_ _215_ VPWR VGND sg13cmos5l_and3_1
X_571_ _217_ _208_ _211_ VPWR VGND sg13cmos5l_xnor2_1
X_572_ _218_ _216_ _217_ _212_ VPWR VGND sg13cmos5l_a21oi_1
X_573_ _219_ _209_ _218_ VPWR VGND sg13cmos5l_nor2_1
X_574_ _220_ _203_ _208_ _219_ VPWR VGND sg13cmos5l_a21oi_1
X_575_ _221_ _205_ _220_ _204_ VPWR VGND sg13cmos5l_o21ai_1
X_576_ _222_ _194_ _200_ VPWR VGND sg13cmos5l_nor2_1
X_577_ _223_ _201_ _221_ _222_ VPWR VGND sg13cmos5l_a21o_1
X_578_ _224_ _201_ _221_ _222_ VPWR VGND sg13cmos5l_a21oi_1
X_579_ _225_ _190_ _195_ VPWR VGND sg13cmos5l_and2_1
X_580_ _226_ _197_ _223_ _225_ VPWR VGND sg13cmos5l_a21o_1
X_581_ _227_ _178_ _191_ _192_ _226_ VPWR VGND sg13cmos5l_a22oi_1
X_582_ _228_ _188_ _227_ _184_ VPWR VGND sg13cmos5l_o21ai_1
X_583_ _229_ _152_ _154_ VPWR VGND sg13cmos5l_nor2_1
X_584_ _230_ _081_ _095_ _080_ VPWR VGND sg13cmos5l_a21oi_1
X_585_ _231_ _150_ _230_ VPWR VGND sg13cmos5l_and2_1
X_586_ _232_ _150_ _230_ VPWR VGND sg13cmos5l_or2_1
X_587_ _233_ _231_ _232_ VPWR VGND sg13cmos5l_nand2b_1
X_588_ _234_ _229_ _233_ VPWR VGND sg13cmos5l_xor2_1
X_589_ _235_ _234_ _186_ VPWR VGND sg13cmos5l_nor2b_1
X_590_ _236_ _186_ _234_ VPWR VGND sg13cmos5l_nor2b_1
X_591_ _237_ _180_ _235_ _236_ VPWR VGND sg13cmos5l_nor3_1
X_592_ _238_ _187_ _237_ VPWR VGND sg13cmos5l_or2_1
X_593_ _239_ _187_ _234_ VPWR VGND sg13cmos5l_nand2_1
X_594_ _240_ _187_ _237_ _239_ VPWR VGND sg13cmos5l_o21ai_1
X_595_ _241_ _228_ _240_ VPWR VGND sg13cmos5l_xor2_1
X_596_ _242_ _229_ _232_ _231_ VPWR VGND sg13cmos5l_a21oi_1
X_597_ _243_ _082_ _095_ VPWR VGND sg13cmos5l_nor2_1
X_598_ _244_ _085_ _095_ _243_ VPWR VGND sg13cmos5l_a21oi_1
X_599_ _245_ _242_ _244_ VPWR VGND sg13cmos5l_nor2_1
X_600_ _246_ _082_ _095_ _236_ _242_ VPWR VGND sg13cmos5l_nor4_1
X_601_ _247_ _180_ _246_ _239_ VPWR VGND sg13cmos5l_o21ai_1
X_602_ _248_ _228_ _238_ _245_ _237_ _247_ VPWR VGND sg13cmos5l_a221oi_1
X_603_ _249_ _189_ _227_ VPWR VGND sg13cmos5l_xor2_1
X_604_ _250_ _183_ _191_ _193_ VPWR VGND sg13cmos5l_o21ai_1
X_605_ _251_ _226_ _250_ VPWR VGND sg13cmos5l_xnor2_1
X_606_ _252_ _197_ _224_ VPWR VGND sg13cmos5l_xnor2_1
X_607_ _253_ _194_ _200_ _201_ VPWR VGND sg13cmos5l_o21ai_1
X_608_ _254_ _221_ _253_ VPWR VGND sg13cmos5l_xnor2_1
X_609_ _255_ _205_ _220_ VPWR VGND sg13cmos5l_xor2_1
X_610_ _256_ _203_ _208_ VPWR VGND sg13cmos5l_xor2_1
X_611_ _257_ _218_ _256_ VPWR VGND sg13cmos5l_xnor2_1
X_612_ _258_ _252_ _254_ _255_ _257_ VPWR VGND sg13cmos5l_nor4_1
X_613_ _259_ _251_ _258_ VPWR VGND sg13cmos5l_nor2b_1
X_614_ _260_ _241_ _248_ _249_ _259_ VPWR VGND sg13cmos5l_nand4_1
X_615_ _261_ _033_ _260_ VPWR VGND sg13cmos5l_nand2_1
X_616_ _262_ busy_s seen_busy VPWR VGND sg13cmos5l_nor2b_1
X_617_ _263_ state\[2\] _033_ _260_ _262_ VPWR VGND sg13cmos5l_nand4_1
X_618_ _264_ rail\[1\] rail\[0\] VPWR VGND sg13cmos5l_nand2_1
X_619_ _265_ net8 net5 net2 VPWR VGND sg13cmos5l_nor3_1
X_620_ _266_ net7 net6 net4 net3 VPWR VGND sg13cmos5l_nor4_1
X_621_ _267_ _369_ _265_ _266_ VPWR VGND sg13cmos5l_nand3_1
X_622_ _268_ net4 net3 net2 net9 VPWR VGND sg13cmos5l_nand4_1
X_623_ _269_ net8 net7 net6 net5 VPWR VGND sg13cmos5l_nand4_1
X_624_ _270_ _268_ _269_ _267_ VPWR VGND sg13cmos5l_o21ai_1
X_625_ _271_ rail\[1\] rail\[0\] rail\[2\] _270_ VPWR VGND  sg13cmos5l_and4_1
X_626_ _272_ _031_ inj_q miss\[1\] VPWR VGND sg13cmos5l_nor3_1
X_627_ _273_ _271_ _272_ net45 VPWR VGND sg13cmos5l_o21ai_1
X_628_ _274_ _263_ _273_ VPWR VGND sg13cmos5l_and2_1
X_629_ _275_ net40 net11 VPWR VGND sg13cmos5l_and2_1
X_630_ _276_ net40 net11 VPWR VGND sg13cmos5l_nand2_1
X_631_ _277_ tmo\[1\] tmo\[0\] tmo\[2\] VPWR VGND sg13cmos5l_nand3_1
X_632_ _278_ _372_ _277_ VPWR VGND sg13cmos5l_nor2_1
X_633_ _279_ tmo\[4\] _278_ VPWR VGND sg13cmos5l_and2_1
X_634_ _280_ _005_ _275_ _279_ VPWR VGND sg13cmos5l_nor3_1
X_635_ _009_ _280_ _274_ VPWR VGND sg13cmos5l_nor2b_1
X_636_ _281_ net45 state\[2\] VPWR VGND sg13cmos5l_nor2_1
X_637_ _282_ _262_ state\[2\] VPWR VGND sg13cmos5l_nand2b_1
X_638_ _283_ _279_ _282_ VPWR VGND sg13cmos5l_nor2_1
X_639_ _284_ _005_ _281_ _283_ VPWR VGND sg13cmos5l_a21o_1
X_640_ _001_ _005_ _276_ VPWR VGND sg13cmos5l_nor2_1
X_641_ _285_ _276_ _279_ _005_ VPWR VGND sg13cmos5l_a21oi_1
X_642_ _286_ _284_ _285_ VPWR VGND sg13cmos5l_nor2_1
X_643_ _008_ _274_ _286_ VPWR VGND sg13cmos5l_and2_1
X_644_ _287_ _271_ net45 VPWR VGND sg13cmos5l_nand2b_1
X_645_ _288_ _272_ _287_ VPWR VGND sg13cmos5l_nor2_1
X_646_ _289_ _270_ _288_ VPWR VGND sg13cmos5l_nand2_1
X_647_ _290_ rail\[1\] rail\[0\] VPWR VGND sg13cmos5l_xnor2_1
X_648_ _000_\[1\] _289_ _290_ VPWR VGND sg13cmos5l_nor2_1
X_649_ _000_\[0\] rail\[0\] _289_ VPWR VGND sg13cmos5l_nor2_1
X_650_ _291_ state\[2\] _261_ _262_ VPWR VGND sg13cmos5l_nand3_1
X_651_ _292_ _005_ _275_ _282_ VPWR VGND sg13cmos5l_o21ai_1
X_652_ _293_ _279_ _292_ _288_ VPWR VGND sg13cmos5l_a21oi_1
X_653_ _002_ _291_ _293_ VPWR VGND sg13cmos5l_nand2_1
X_654_ _003_ _283_ _001_ VPWR VGND sg13cmos5l_or2_1
X_655_ _294_ rail\[2\] _264_ VPWR VGND sg13cmos5l_xor2_1
X_656_ _000_\[2\] _289_ _294_ VPWR VGND sg13cmos5l_nor2_1
X_657_ _295_ state\[2\] net45 VPWR VGND sg13cmos5l_nand2b_1
X_658_ _296_ _263_ _295_ _288_ VPWR VGND sg13cmos5l_a21oi_1
X_659_ _297_ _216_ _217_ VPWR VGND sg13cmos5l_xor2_1
X_660_ _298_ net2 _297_ VPWR VGND sg13cmos5l_nand2_1
X_661_ _299_ net2 _297_ VPWR VGND sg13cmos5l_xnor2_1
X_662_ _300_ _368_ _249_ VPWR VGND sg13cmos5l_nor2_1
X_663_ _301_ net8 _249_ VPWR VGND sg13cmos5l_xnor2_1
X_664_ _302_ net7 _251_ VPWR VGND sg13cmos5l_nand2_1
X_665_ _303_ net6 _252_ VPWR VGND sg13cmos5l_and2_1
X_666_ _304_ net5 _254_ VPWR VGND sg13cmos5l_nand2_1
X_667_ _305_ net4 _255_ VPWR VGND sg13cmos5l_and2_1
X_668_ _306_ net3 _257_ VPWR VGND sg13cmos5l_nand2_1
X_669_ _307_ net3 _257_ VPWR VGND sg13cmos5l_xnor2_1
X_670_ _308_ _298_ _307_ _306_ VPWR VGND sg13cmos5l_o21ai_1
X_671_ _309_ net4 _255_ VPWR VGND sg13cmos5l_xor2_1
X_672_ _310_ _308_ _309_ _305_ VPWR VGND sg13cmos5l_a21oi_1
X_673_ _311_ net5 _254_ VPWR VGND sg13cmos5l_xnor2_1
X_674_ _312_ _310_ _311_ _304_ VPWR VGND sg13cmos5l_o21ai_1
X_675_ _313_ net6 _252_ VPWR VGND sg13cmos5l_xor2_1
X_676_ _314_ _312_ _313_ _303_ VPWR VGND sg13cmos5l_a21oi_1
X_677_ _315_ net7 _251_ VPWR VGND sg13cmos5l_xnor2_1
X_678_ _316_ _314_ _315_ _302_ VPWR VGND sg13cmos5l_o21ai_1
X_679_ _317_ _301_ _316_ _300_ VPWR VGND sg13cmos5l_a21o_1
X_680_ _318_ _369_ _241_ _248_ VPWR VGND sg13cmos5l_o21ai_1
X_681_ _319_ _369_ _241_ _248_ VPWR VGND sg13cmos5l_nand3_1
X_682_ _320_ _317_ _318_ _319_ VPWR VGND sg13cmos5l_o21ai_1
X_683_ _321_ _299_ _320_ net44 VPWR VGND sg13cmos5l_a21oi_1
X_684_ _010_ net31 _321_ _296_ VPWR VGND sg13cmos5l_mux2_1
X_685_ _322_ _301_ _316_ VPWR VGND sg13cmos5l_xnor2_1
X_686_ _323_ _320_ _322_ net44 VPWR VGND sg13cmos5l_a21oi_1
X_687_ _011_ net37 _323_ _296_ VPWR VGND sg13cmos5l_mux2_1
X_688_ _324_ _314_ _315_ VPWR VGND sg13cmos5l_xnor2_1
X_689_ _325_ _320_ _324_ net44 VPWR VGND sg13cmos5l_a21oi_1
X_690_ _012_ net36 _325_ _296_ VPWR VGND sg13cmos5l_mux2_1
X_691_ _326_ _005_ _281_ _288_ VPWR VGND sg13cmos5l_a21oi_1
X_692_ _327_ _326_ VPWR VGND sg13cmos5l_inv_1
X_693_ _328_ _277_ _326_ VPWR VGND sg13cmos5l_nand2b_1
X_694_ _329_ _276_ _281_ VPWR VGND sg13cmos5l_nand2_1
X_695_ _330_ _282_ _329_ VPWR VGND sg13cmos5l_nand2_1
X_696_ _331_ _330_ VPWR VGND sg13cmos5l_inv_1
X_697_ _332_ _278_ _331_ VPWR VGND sg13cmos5l_nor2_1
X_698_ _333_ _327_ _332_ VPWR VGND sg13cmos5l_nor2_1
X_699_ _013_ _372_ _328_ _333_ VPWR VGND sg13cmos5l_a21oi_1
X_700_ _334_ tmo\[1\] tmo\[0\] _326_ VPWR VGND sg13cmos5l_nand3_1
X_701_ _335_ _277_ _330_ VPWR VGND sg13cmos5l_nand2_1
X_702_ _014_ _371_ _334_ _335_ _326_ VPWR VGND sg13cmos5l_a22oi_1
X_703_ _336_ _327_ _331_ VPWR VGND sg13cmos5l_nor2_1
X_704_ _337_ _278_ _336_ tmo\[4\] VPWR VGND sg13cmos5l_a21oi_1
X_705_ _015_ tmo\[4\] _333_ _337_ VPWR VGND sg13cmos5l_a21oi_1
X_706_ _338_ miss\[0\] inj_q _287_ VPWR VGND sg13cmos5l_nor3_1
X_707_ _339_ _271_ inj_q net44 VPWR VGND sg13cmos5l_nand3b_1
X_708_ _340_ irun\[1\] irun\[0\] irun\[2\] VPWR VGND sg13cmos5l_nand3_1
X_709_ _341_ _032_ _340_ VPWR VGND sg13cmos5l_or2_1
X_710_ _342_ _339_ _341_ VPWR VGND sg13cmos5l_nor2b_1
X_711_ _016_ miss\[0\] _342_ _338_ VPWR VGND sg13cmos5l_a21o_1
X_712_ _343_ busy_s seen_busy VPWR VGND sg13cmos5l_nor2_1
X_713_ _344_ seen_busy _005_ state\[2\] VPWR VGND sg13cmos5l_a21oi_1
X_714_ _017_ _343_ _344_ VPWR VGND sg13cmos5l_nor2_1
X_715_ _345_ tmo\[0\] _331_ _326_ VPWR VGND sg13cmos5l_o21ai_1
X_716_ _346_ tmo\[1\] _345_ VPWR VGND sg13cmos5l_nand2_1
X_717_ _347_ tmo\[1\] tmo\[0\] _336_ VPWR VGND sg13cmos5l_nand3b_1
X_718_ _018_ _346_ _347_ VPWR VGND sg13cmos5l_nand2_1
X_719_ _348_ _338_ _342_ miss\[1\] VPWR VGND sg13cmos5l_o21ai_1
X_720_ _019_ _348_ VPWR VGND sg13cmos5l_inv_1
X_721_ _349_ tmo\[0\] _326_ _345_ VPWR VGND sg13cmos5l_o21ai_1
X_722_ _020_ _349_ VPWR VGND sg13cmos5l_inv_1
X_723_ _350_ _312_ _313_ VPWR VGND sg13cmos5l_xnor2_1
X_724_ _351_ _370_ _320_ _350_ VPWR VGND sg13cmos5l_and3_1
X_725_ _021_ _006_ _351_ _296_ VPWR VGND sg13cmos5l_mux2_1
X_726_ _352_ net40 _284_ _285_ _281_ VPWR VGND sg13cmos5l_a22oi_1
X_727_ _022_ _352_ VPWR VGND sg13cmos5l_inv_1
X_728_ _353_ _310_ _311_ VPWR VGND sg13cmos5l_xnor2_1
X_729_ _354_ _370_ _320_ _353_ VPWR VGND sg13cmos5l_and3_1
X_730_ _023_ _007_ _354_ _296_ VPWR VGND sg13cmos5l_mux2_1
X_731_ _024_ _032_ _340_ _339_ VPWR VGND sg13cmos5l_a21oi_1
X_732_ _355_ irun\[3\] _340_ VPWR VGND sg13cmos5l_nor2_1
X_733_ _356_ irun\[1\] irun\[0\] irun\[2\] VPWR VGND sg13cmos5l_a21oi_1
X_734_ _025_ _339_ _355_ _356_ VPWR VGND sg13cmos5l_nor3_1
X_735_ _357_ irun\[1\] irun\[0\] VPWR VGND sg13cmos5l_xnor2_1
X_736_ _026_ _341_ _357_ _339_ VPWR VGND sg13cmos5l_a21oi_1
X_737_ _027_ irun\[0\] _341_ _339_ VPWR VGND sg13cmos5l_a21oi_1
X_738_ _358_ _308_ _309_ VPWR VGND sg13cmos5l_xnor2_1
X_739_ _359_ _320_ _358_ net44 VPWR VGND sg13cmos5l_a21oi_1
X_740_ _028_ net33 _359_ _296_ VPWR VGND sg13cmos5l_mux2_1
X_741_ _360_ _298_ _307_ VPWR VGND sg13cmos5l_xnor2_1
X_742_ _361_ _320_ _360_ net44 VPWR VGND sg13cmos5l_a21oi_1
X_743_ _029_ net32 _361_ _296_ VPWR VGND sg13cmos5l_mux2_1
X_744_ _362_ _317_ _319_ VPWR VGND sg13cmos5l_nor2_1
X_745_ _363_ net44 _362_ VPWR VGND sg13cmos5l_nor2_1
X_746_ _030_ net38 _363_ _296_ VPWR VGND sg13cmos5l_mux2_1
X_747_ seen_busy clknet_3_5__leaf_clk _017_ net50 VPWR VGND  sg13cmos5l_dfrbpq_1
X_748_ miss\[0\] clknet_3_6__leaf_clk _016_ net48 VPWR VGND  sg13cmos5l_dfrbpq_1
X_749_ miss\[1\] clknet_3_6__leaf_clk _019_ net48 VPWR VGND  sg13cmos5l_dfrbpq_1
X_750_ net40 clknet_3_4__leaf_clk _022_ net50 VPWR VGND sg13cmos5l_dfrbpq_1
X_751_ irun\[0\] clknet_3_1__leaf_clk _027_ net48 VPWR VGND  sg13cmos5l_dfrbpq_1
X_752_ irun\[1\] clknet_3_1__leaf_clk _026_ net47 VPWR VGND  sg13cmos5l_dfrbpq_1
X_753_ irun\[2\] clknet_3_3__leaf_clk _025_ net47 VPWR VGND  sg13cmos5l_dfrbpq_1
X_754_ irun\[3\] clknet_3_0__leaf_clk _024_ net47 VPWR VGND  sg13cmos5l_dfrbpq_1
X_755_ tmo\[0\] clknet_3_6__leaf_clk _020_ net48 VPWR VGND  sg13cmos5l_dfrbpq_1
X_756_ tmo\[1\] clknet_3_6__leaf_clk _018_ net48 VPWR VGND  sg13cmos5l_dfrbpq_1
X_757_ tmo\[2\] clknet_3_7__leaf_clk _014_ net48 VPWR VGND  sg13cmos5l_dfrbpq_1
X_758_ tmo\[3\] clknet_3_7__leaf_clk _013_ net49 VPWR VGND  sg13cmos5l_dfrbpq_1
X_759_ tmo\[4\] clknet_3_7__leaf_clk _015_ net49 VPWR VGND  sg13cmos5l_dfrbpq_1
X_760_ net31 clknet_3_3__leaf_clk _010_ net46 VPWR VGND sg13cmos5l_dfrbpq_1
X_761_ net32 clknet_3_2__leaf_clk _029_ net46 VPWR VGND sg13cmos5l_dfrbpq_1
X_762_ net33 clknet_3_0__leaf_clk _028_ net46 VPWR VGND sg13cmos5l_dfrbpq_1
X_763_ _007_ clknet_3_0__leaf_clk _023_ net46 VPWR VGND sg13cmos5l_dfrbpq_1
X_764_ _006_ clknet_3_0__leaf_clk _021_ net46 VPWR VGND sg13cmos5l_dfrbpq_1
X_765_ net36 clknet_3_3__leaf_clk _012_ net46 VPWR VGND sg13cmos5l_dfrbpq_1
X_766_ net37 clknet_3_2__leaf_clk _011_ net46 VPWR VGND sg13cmos5l_dfrbpq_1
X_767_ net38 clknet_3_2__leaf_clk _030_ net46 VPWR VGND sg13cmos5l_dfrbpq_1
X_768_ _005_ clknet_3_4__leaf_clk _009_ net49 VPWR VGND sg13cmos5l_dfrbpq_1
X_769_ net30 clknet_3_7__leaf_clk _002_ net49 VPWR VGND sg13cmos5l_dfrbpq_1
X_770_ state\[2\] clknet_3_4__leaf_clk _003_ net50 VPWR VGND  sg13cmos5l_dfrbpq_1
X_771_ net39 clknet_3_5__leaf_clk _001_ net50 VPWR VGND sg13cmos5l_dfrbpq_1
X_772_ _004_ clknet_3_2__leaf_clk _008_ net47 VPWR VGND sg13cmos5l_dfrbpq_1
X_773_ inj_q clknet_3_4__leaf_clk net11 net48 VPWR VGND sg13cmos5l_dfrbpq_1
X_774_ rail\[0\] clknet_3_3__leaf_clk _000_\[0\] net47 VPWR  VGND sg13cmos5l_dfrbpq_1
X_775_ rail\[1\] clknet_3_1__leaf_clk _000_\[1\] net47 VPWR  VGND sg13cmos5l_dfrbpq_1
X_776_ rail\[2\] clknet_3_1__leaf_clk _000_\[2\] net48 VPWR  VGND sg13cmos5l_dfrbpq_1
X_777_ busy_m clknet_3_5__leaf_clk net1 net50 VPWR VGND sg13cmos5l_dfrbpq_1
X_778_ busy_s clknet_3_5__leaf_clk net60 net50 VPWR VGND sg13cmos5l_dfrbpq_1
Xinput1 net1 busy VPWR VGND sg13cmos5l_buf_1
Xinput2 net2 code[0] VPWR VGND sg13cmos5l_buf_1
Xinput3 net3 code[1] VPWR VGND sg13cmos5l_buf_1
Xinput4 net4 code[2] VPWR VGND sg13cmos5l_buf_1
Xinput5 net5 code[3] VPWR VGND sg13cmos5l_buf_1
Xinput6 net6 code[4] VPWR VGND sg13cmos5l_buf_1
Xinput7 net7 code[5] VPWR VGND sg13cmos5l_buf_1
Xinput8 net8 code[6] VPWR VGND sg13cmos5l_buf_1
Xinput9 net9 code[7] VPWR VGND sg13cmos5l_buf_1
Xinput10 net10 hit VPWR VGND sg13cmos5l_buf_1
Xinput11 net11 inj VPWR VGND sg13cmos5l_buf_1
Xinput12 net12 resetb VPWR VGND sg13cmos5l_buf_1
Xinput13 net13 tdc_f[0] VPWR VGND sg13cmos5l_buf_1
Xinput14 net14 tdc_f[1] VPWR VGND sg13cmos5l_buf_1
Xinput15 net15 tdc_f[2] VPWR VGND sg13cmos5l_buf_1
Xinput16 net16 tdc_f[3] VPWR VGND sg13cmos5l_buf_1
Xinput17 net17 tdc_f[4] VPWR VGND sg13cmos5l_buf_1
Xinput18 net18 tdc_f[5] VPWR VGND sg13cmos5l_buf_1
Xinput19 net19 tdc_f[6] VPWR VGND sg13cmos5l_buf_1
Xinput20 net20 tdc_f[7] VPWR VGND sg13cmos5l_buf_1
Xinput21 net21 tdc_s[0] VPWR VGND sg13cmos5l_buf_1
Xinput22 net22 tdc_s[1] VPWR VGND sg13cmos5l_buf_1
Xinput23 net23 tdc_s[2] VPWR VGND sg13cmos5l_buf_1
Xinput24 net24 tdc_s[3] VPWR VGND sg13cmos5l_buf_1
Xinput25 net25 tdc_s[4] VPWR VGND sg13cmos5l_buf_1
Xinput26 net26 tdc_s[5] VPWR VGND sg13cmos5l_buf_1
Xinput27 net27 tdc_s[6] VPWR VGND sg13cmos5l_buf_1
Xinput28 net28 tdc_s[7] VPWR VGND sg13cmos5l_buf_1
Xoutput29 load net29 VPWR VGND sg13cmos5l_buf_1
Xoutput30 locked net45 VPWR VGND sg13cmos5l_buf_1
Xoutput31 seed[0] net56 VPWR VGND sg13cmos5l_buf_1
Xoutput32 seed[1] net55 VPWR VGND sg13cmos5l_buf_1
Xoutput33 seed[2] net52 VPWR VGND sg13cmos5l_buf_1
Xoutput34 seed[3] net34 VPWR VGND sg13cmos5l_buf_1
Xoutput35 seed[4] net35 VPWR VGND sg13cmos5l_buf_1
Xoutput36 seed[5] net54 VPWR VGND sg13cmos5l_buf_1
Xoutput37 seed[6] net53 VPWR VGND sg13cmos5l_buf_1
Xoutput38 seed[7] net51 VPWR VGND sg13cmos5l_buf_1
Xoutput39 sel net39 VPWR VGND sg13cmos5l_buf_1
Xoutput40 start net40 VPWR VGND sg13cmos5l_buf_1
Xfanout41 net41 _181_ VPWR VGND sg13cmos5l_buf_1
Xfanout42 net42 _044_ VPWR VGND sg13cmos5l_buf_1
Xfanout43 net43 _040_ VPWR VGND sg13cmos5l_buf_1
Xfanout44 net44 net30 VPWR VGND sg13cmos5l_buf_1
Xfanout45 net45 net30 VPWR VGND sg13cmos5l_buf_1
Xfanout46 net46 net12 VPWR VGND sg13cmos5l_buf_1
Xfanout47 net47 net12 VPWR VGND sg13cmos5l_buf_1
Xfanout48 net48 net50 VPWR VGND sg13cmos5l_buf_1
Xfanout49 net49 net50 VPWR VGND sg13cmos5l_buf_1
Xfanout50 net50 net12 VPWR VGND sg13cmos5l_buf_1
Xclkbuf_0_clk clknet_0_clk clk VPWR VGND sg13cmos5l_buf_8
Xclkbuf_3_0__f_clk clknet_3_0__leaf_clk clknet_0_clk VPWR  VGND sg13cmos5l_buf_8
Xclkbuf_3_1__f_clk clknet_3_1__leaf_clk clknet_0_clk VPWR  VGND sg13cmos5l_buf_8
Xclkbuf_3_2__f_clk clknet_3_2__leaf_clk clknet_0_clk VPWR  VGND sg13cmos5l_buf_8
Xclkbuf_3_3__f_clk clknet_3_3__leaf_clk clknet_0_clk VPWR  VGND sg13cmos5l_buf_8
Xclkbuf_3_4__f_clk clknet_3_4__leaf_clk clknet_0_clk VPWR  VGND sg13cmos5l_buf_8
Xclkbuf_3_5__f_clk clknet_3_5__leaf_clk clknet_0_clk VPWR  VGND sg13cmos5l_buf_8
Xclkbuf_3_6__f_clk clknet_3_6__leaf_clk clknet_0_clk VPWR  VGND sg13cmos5l_buf_8
Xclkbuf_3_7__f_clk clknet_3_7__leaf_clk clknet_0_clk VPWR  VGND sg13cmos5l_buf_8
Xhold51 net51 net38 VPWR VGND sg13cmos5l_dlygate4sd3_1
Xhold52 net52 net33 VPWR VGND sg13cmos5l_dlygate4sd3_1
Xhold53 net53 net37 VPWR VGND sg13cmos5l_dlygate4sd3_1
Xhold54 net54 net36 VPWR VGND sg13cmos5l_dlygate4sd3_1
Xhold55 net55 net32 VPWR VGND sg13cmos5l_dlygate4sd3_1
Xhold56 net56 net31 VPWR VGND sg13cmos5l_dlygate4sd3_1
Xhold57 net57 _004_ VPWR VGND sg13cmos5l_dlygate4sd3_1
Xhold58 net58 _007_ VPWR VGND sg13cmos5l_dlygate4sd3_1
Xhold59 net59 _006_ VPWR VGND sg13cmos5l_dlygate4sd3_1
Xhold60 net60 busy_m VPWR VGND sg13cmos5l_dlygate4sd3_1
XFILLER_0_9 VPWR VGND sg13cmos5l_decap_8
XFILLER_0_21 VPWR VGND sg13cmos5l_decap_4
XFILLER_0_29 VPWR VGND sg13cmos5l_decap_4
XFILLER_0_39 VPWR VGND sg13cmos5l_decap_4
XFILLER_0_49 VPWR VGND sg13cmos5l_decap_8
XFILLER_0_89 VPWR VGND sg13cmos5l_decap_8
XFILLER_0_96 VPWR VGND sg13cmos5l_decap_4
XFILLER_0_109 VPWR VGND sg13cmos5l_decap_4
XFILLER_0_134 VPWR VGND sg13cmos5l_decap_8
XFILLER_0_175 VPWR VGND sg13cmos5l_decap_8
XFILLER_0_217 VPWR VGND sg13cmos5l_decap_8
XFILLER_1_0 VPWR VGND sg13cmos5l_decap_8
XFILLER_1_7 VPWR VGND sg13cmos5l_decap_8
XFILLER_1_14 VPWR VGND sg13cmos5l_decap_8
XFILLER_1_21 VPWR VGND sg13cmos5l_decap_8
XFILLER_1_50 VPWR VGND sg13cmos5l_decap_8
XFILLER_1_57 VPWR VGND sg13cmos5l_decap_8
XFILLER_1_92 VPWR VGND sg13cmos5l_decap_8
XFILLER_1_133 VPWR VGND sg13cmos5l_decap_8
XFILLER_1_175 VPWR VGND sg13cmos5l_decap_8
XFILLER_1_215 VPWR VGND sg13cmos5l_decap_8
XFILLER_2_0 VPWR VGND sg13cmos5l_decap_8
XFILLER_2_7 VPWR VGND sg13cmos5l_decap_8
XFILLER_2_50 VPWR VGND sg13cmos5l_decap_8
XFILLER_2_57 VPWR VGND sg13cmos5l_decap_4
XFILLER_2_92 VPWR VGND sg13cmos5l_decap_8
XFILLER_2_109 VPWR VGND sg13cmos5l_decap_8
XFILLER_2_123 VPWR VGND sg13cmos5l_decap_8
XFILLER_2_134 VPWR VGND sg13cmos5l_decap_8
XFILLER_2_175 VPWR VGND sg13cmos5l_decap_8
XFILLER_2_217 VPWR VGND sg13cmos5l_decap_8
XFILLER_3_9 VPWR VGND sg13cmos5l_decap_8
XFILLER_3_34 VPWR VGND sg13cmos5l_decap_4
XFILLER_3_50 VPWR VGND sg13cmos5l_decap_8
XFILLER_3_57 VPWR VGND sg13cmos5l_decap_8
XFILLER_3_64 VPWR VGND sg13cmos5l_decap_8
XFILLER_3_79 VPWR VGND sg13cmos5l_decap_4
XFILLER_3_88 VPWR VGND sg13cmos5l_decap_8
XFILLER_3_95 VPWR VGND sg13cmos5l_decap_8
XFILLER_3_107 VPWR VGND sg13cmos5l_decap_8
XFILLER_3_114 VPWR VGND sg13cmos5l_decap_8
XFILLER_3_121 VPWR VGND sg13cmos5l_decap_8
XFILLER_3_128 VPWR VGND sg13cmos5l_decap_8
XFILLER_3_135 VPWR VGND sg13cmos5l_decap_8
XFILLER_3_175 VPWR VGND sg13cmos5l_decap_8
XFILLER_3_214 VPWR VGND sg13cmos5l_decap_8
XFILLER_3_221 VPWR VGND sg13cmos5l_decap_8
XFILLER_3_228 VPWR VGND sg13cmos5l_decap_4
XFILLER_4_0 VPWR VGND sg13cmos5l_decap_8
XFILLER_4_7 VPWR VGND sg13cmos5l_decap_8
XFILLER_4_22 VPWR VGND sg13cmos5l_decap_8
XFILLER_4_44 VPWR VGND sg13cmos5l_decap_8
XFILLER_4_51 VPWR VGND sg13cmos5l_decap_8
XFILLER_4_64 VPWR VGND sg13cmos5l_decap_8
XFILLER_4_71 VPWR VGND sg13cmos5l_decap_8
XFILLER_4_78 VPWR VGND sg13cmos5l_decap_8
XFILLER_4_85 VPWR VGND sg13cmos5l_decap_8
XFILLER_4_92 VPWR VGND sg13cmos5l_decap_8
XFILLER_4_121 VPWR VGND sg13cmos5l_decap_4
XFILLER_4_134 VPWR VGND sg13cmos5l_decap_8
XFILLER_4_175 VPWR VGND sg13cmos5l_decap_8
XFILLER_4_182 VPWR VGND sg13cmos5l_decap_4
XFILLER_4_216 VPWR VGND sg13cmos5l_decap_8
XFILLER_4_223 VPWR VGND sg13cmos5l_decap_8
XFILLER_5_9 VPWR VGND sg13cmos5l_decap_8
XFILLER_5_22 VPWR VGND sg13cmos5l_decap_4
XFILLER_5_31 VPWR VGND sg13cmos5l_decap_8
XFILLER_5_38 VPWR VGND sg13cmos5l_decap_4
XFILLER_5_50 VPWR VGND sg13cmos5l_decap_8
XFILLER_5_92 VPWR VGND sg13cmos5l_decap_8
XFILLER_5_99 VPWR VGND sg13cmos5l_decap_4
XFILLER_5_134 VPWR VGND sg13cmos5l_decap_8
XFILLER_5_175 VPWR VGND sg13cmos5l_decap_8
XFILLER_5_217 VPWR VGND sg13cmos5l_decap_8
XFILLER_5_224 VPWR VGND sg13cmos5l_decap_8
XFILLER_6_0 VPWR VGND sg13cmos5l_decap_4
XFILLER_6_9 VPWR VGND sg13cmos5l_decap_8
XFILLER_6_16 VPWR VGND sg13cmos5l_decap_4
XFILLER_6_40 VPWR VGND sg13cmos5l_decap_4
XFILLER_6_50 VPWR VGND sg13cmos5l_decap_8
XFILLER_6_64 VPWR VGND sg13cmos5l_decap_4
XFILLER_6_91 VPWR VGND sg13cmos5l_decap_8
XFILLER_6_98 VPWR VGND sg13cmos5l_decap_8
XFILLER_6_105 VPWR VGND sg13cmos5l_decap_8
XFILLER_6_123 VPWR VGND sg13cmos5l_decap_4
XFILLER_6_134 VPWR VGND sg13cmos5l_decap_8
XFILLER_6_146 VPWR VGND sg13cmos5l_decap_4
XFILLER_6_175 VPWR VGND sg13cmos5l_decap_8
XFILLER_6_211 VPWR VGND sg13cmos5l_decap_8
XFILLER_6_218 VPWR VGND sg13cmos5l_decap_8
XFILLER_6_225 VPWR VGND sg13cmos5l_decap_8
XFILLER_7_0 VPWR VGND sg13cmos5l_decap_4
XFILLER_7_9 VPWR VGND sg13cmos5l_decap_8
XFILLER_7_16 VPWR VGND sg13cmos5l_decap_8
XFILLER_7_23 VPWR VGND sg13cmos5l_decap_8
XFILLER_7_30 VPWR VGND sg13cmos5l_decap_8
XFILLER_7_37 VPWR VGND sg13cmos5l_decap_4
XFILLER_7_50 VPWR VGND sg13cmos5l_decap_8
XFILLER_7_57 VPWR VGND sg13cmos5l_decap_8
XFILLER_7_64 VPWR VGND sg13cmos5l_decap_8
XFILLER_7_82 VPWR VGND sg13cmos5l_decap_4
XFILLER_7_92 VPWR VGND sg13cmos5l_decap_8
XFILLER_7_99 VPWR VGND sg13cmos5l_decap_8
XFILLER_7_106 VPWR VGND sg13cmos5l_decap_4
XFILLER_7_115 VPWR VGND sg13cmos5l_decap_8
XFILLER_7_122 VPWR VGND sg13cmos5l_decap_8
XFILLER_7_129 VPWR VGND sg13cmos5l_decap_8
XFILLER_7_136 VPWR VGND sg13cmos5l_decap_4
XFILLER_7_150 VPWR VGND sg13cmos5l_decap_8
XFILLER_7_157 VPWR VGND sg13cmos5l_decap_4
XFILLER_7_175 VPWR VGND sg13cmos5l_decap_8
XFILLER_7_211 VPWR VGND sg13cmos5l_decap_8
XFILLER_7_218 VPWR VGND sg13cmos5l_decap_8
XFILLER_7_225 VPWR VGND sg13cmos5l_decap_8
XFILLER_8_9 VPWR VGND sg13cmos5l_decap_8
XFILLER_8_21 VPWR VGND sg13cmos5l_decap_8
XFILLER_8_28 VPWR VGND sg13cmos5l_decap_4
XFILLER_8_50 VPWR VGND sg13cmos5l_decap_8
XFILLER_8_72 VPWR VGND sg13cmos5l_decap_8
XFILLER_8_92 VPWR VGND sg13cmos5l_decap_8
XFILLER_8_125 VPWR VGND sg13cmos5l_decap_4
XFILLER_8_134 VPWR VGND sg13cmos5l_decap_8
XFILLER_8_150 VPWR VGND sg13cmos5l_decap_8
XFILLER_8_157 VPWR VGND sg13cmos5l_decap_4
XFILLER_8_175 VPWR VGND sg13cmos5l_decap_8
XFILLER_8_214 VPWR VGND sg13cmos5l_decap_8
XFILLER_8_221 VPWR VGND sg13cmos5l_decap_8
XFILLER_8_228 VPWR VGND sg13cmos5l_decap_4
XFILLER_9_0 VPWR VGND sg13cmos5l_decap_4
XFILLER_9_9 VPWR VGND sg13cmos5l_decap_8
XFILLER_9_50 VPWR VGND sg13cmos5l_decap_8
XFILLER_9_67 VPWR VGND sg13cmos5l_decap_4
XFILLER_9_79 VPWR VGND sg13cmos5l_decap_8
XFILLER_9_92 VPWR VGND sg13cmos5l_decap_8
XFILLER_9_99 VPWR VGND sg13cmos5l_decap_8
XFILLER_9_106 VPWR VGND sg13cmos5l_decap_4
XFILLER_9_118 VPWR VGND sg13cmos5l_decap_4
XFILLER_9_134 VPWR VGND sg13cmos5l_decap_8
XFILLER_9_175 VPWR VGND sg13cmos5l_decap_8
XFILLER_9_182 VPWR VGND sg13cmos5l_decap_4
XFILLER_9_217 VPWR VGND sg13cmos5l_decap_8
XFILLER_9_224 VPWR VGND sg13cmos5l_decap_8
XFILLER_10_0 VPWR VGND sg13cmos5l_decap_4
XFILLER_10_9 VPWR VGND sg13cmos5l_decap_8
XFILLER_10_16 VPWR VGND sg13cmos5l_decap_8
XFILLER_10_23 VPWR VGND sg13cmos5l_decap_8
XFILLER_10_35 VPWR VGND sg13cmos5l_decap_4
XFILLER_10_48 VPWR VGND sg13cmos5l_decap_8
XFILLER_10_55 VPWR VGND sg13cmos5l_decap_4
XFILLER_10_72 VPWR VGND sg13cmos5l_decap_8
XFILLER_10_92 VPWR VGND sg13cmos5l_decap_8
XFILLER_10_99 VPWR VGND sg13cmos5l_decap_8
XFILLER_10_106 VPWR VGND sg13cmos5l_decap_8
XFILLER_10_113 VPWR VGND sg13cmos5l_decap_8
XFILLER_10_120 VPWR VGND sg13cmos5l_decap_8
XFILLER_10_134 VPWR VGND sg13cmos5l_decap_8
XFILLER_10_149 VPWR VGND sg13cmos5l_decap_8
XFILLER_10_156 VPWR VGND sg13cmos5l_decap_8
XFILLER_10_175 VPWR VGND sg13cmos5l_decap_8
XFILLER_10_216 VPWR VGND sg13cmos5l_decap_8
XFILLER_11_9 VPWR VGND sg13cmos5l_decap_8
XFILLER_11_22 VPWR VGND sg13cmos5l_decap_8
XFILLER_11_35 VPWR VGND sg13cmos5l_decap_4
XFILLER_11_50 VPWR VGND sg13cmos5l_decap_8
XFILLER_11_57 VPWR VGND sg13cmos5l_decap_8
XFILLER_11_64 VPWR VGND sg13cmos5l_decap_8
XFILLER_11_71 VPWR VGND sg13cmos5l_decap_8
XFILLER_11_92 VPWR VGND sg13cmos5l_decap_8
XFILLER_11_134 VPWR VGND sg13cmos5l_decap_8
XFILLER_11_141 VPWR VGND sg13cmos5l_decap_8
XFILLER_11_175 VPWR VGND sg13cmos5l_decap_8
XFILLER_11_217 VPWR VGND sg13cmos5l_decap_8
XFILLER_12_9 VPWR VGND sg13cmos5l_decap_8
XFILLER_12_50 VPWR VGND sg13cmos5l_decap_8
XFILLER_12_67 VPWR VGND sg13cmos5l_decap_8
XFILLER_12_74 VPWR VGND sg13cmos5l_decap_4
XFILLER_12_92 VPWR VGND sg13cmos5l_decap_8
XFILLER_12_99 VPWR VGND sg13cmos5l_decap_8
XFILLER_12_134 VPWR VGND sg13cmos5l_decap_8
XFILLER_12_150 VPWR VGND sg13cmos5l_decap_8
XFILLER_12_166 VPWR VGND sg13cmos5l_decap_8
XFILLER_12_173 VPWR VGND sg13cmos5l_decap_8
XFILLER_12_180 VPWR VGND sg13cmos5l_decap_8
XFILLER_12_217 VPWR VGND sg13cmos5l_decap_8
XFILLER_12_224 VPWR VGND sg13cmos5l_decap_8
XFILLER_13_0 VPWR VGND sg13cmos5l_decap_8
XFILLER_13_7 VPWR VGND sg13cmos5l_decap_8
XFILLER_13_14 VPWR VGND sg13cmos5l_decap_4
XFILLER_13_22 VPWR VGND sg13cmos5l_decap_4
XFILLER_13_33 VPWR VGND sg13cmos5l_decap_8
XFILLER_13_40 VPWR VGND sg13cmos5l_decap_4
XFILLER_13_50 VPWR VGND sg13cmos5l_decap_8
XFILLER_13_64 VPWR VGND sg13cmos5l_decap_4
XFILLER_13_77 VPWR VGND sg13cmos5l_decap_8
XFILLER_13_84 VPWR VGND sg13cmos5l_decap_4
XFILLER_13_91 VPWR VGND sg13cmos5l_decap_8
XFILLER_13_98 VPWR VGND sg13cmos5l_decap_8
XFILLER_13_105 VPWR VGND sg13cmos5l_decap_8
XFILLER_13_112 VPWR VGND sg13cmos5l_decap_8
XFILLER_13_134 VPWR VGND sg13cmos5l_decap_8
XFILLER_13_141 VPWR VGND sg13cmos5l_decap_8
XFILLER_13_148 VPWR VGND sg13cmos5l_decap_8
XFILLER_13_172 VPWR VGND sg13cmos5l_decap_8
XFILLER_13_179 VPWR VGND sg13cmos5l_decap_4
XFILLER_13_216 VPWR VGND sg13cmos5l_decap_8
XFILLER_13_223 VPWR VGND sg13cmos5l_decap_8
XFILLER_14_0 VPWR VGND sg13cmos5l_decap_4
XFILLER_14_9 VPWR VGND sg13cmos5l_decap_8
XFILLER_14_30 VPWR VGND sg13cmos5l_decap_8
XFILLER_14_37 VPWR VGND sg13cmos5l_decap_8
XFILLER_14_44 VPWR VGND sg13cmos5l_decap_8
XFILLER_14_51 VPWR VGND sg13cmos5l_decap_8
XFILLER_14_92 VPWR VGND sg13cmos5l_decap_8
XFILLER_14_112 VPWR VGND sg13cmos5l_decap_4
XFILLER_14_133 VPWR VGND sg13cmos5l_decap_8
XFILLER_14_140 VPWR VGND sg13cmos5l_decap_8
XFILLER_14_147 VPWR VGND sg13cmos5l_decap_4
XFILLER_14_173 VPWR VGND sg13cmos5l_decap_8
XFILLER_14_180 VPWR VGND sg13cmos5l_decap_8
XFILLER_14_217 VPWR VGND sg13cmos5l_decap_8
XFILLER_14_224 VPWR VGND sg13cmos5l_decap_8
XFILLER_15_9 VPWR VGND sg13cmos5l_decap_8
XFILLER_15_33 VPWR VGND sg13cmos5l_decap_8
XFILLER_15_50 VPWR VGND sg13cmos5l_decap_8
XFILLER_15_57 VPWR VGND sg13cmos5l_decap_8
XFILLER_15_64 VPWR VGND sg13cmos5l_decap_4
XFILLER_15_79 VPWR VGND sg13cmos5l_decap_8
XFILLER_15_92 VPWR VGND sg13cmos5l_decap_8
XFILLER_15_132 VPWR VGND sg13cmos5l_decap_8
XFILLER_15_175 VPWR VGND sg13cmos5l_decap_8
XFILLER_15_182 VPWR VGND sg13cmos5l_decap_4
XFILLER_15_209 VPWR VGND sg13cmos5l_decap_8
XFILLER_15_216 VPWR VGND sg13cmos5l_decap_8
XFILLER_15_223 VPWR VGND sg13cmos5l_decap_8
XFILLER_16_0 VPWR VGND sg13cmos5l_decap_4
XFILLER_16_9 VPWR VGND sg13cmos5l_decap_8
XFILLER_16_28 VPWR VGND sg13cmos5l_decap_4
XFILLER_16_50 VPWR VGND sg13cmos5l_decap_8
XFILLER_16_80 VPWR VGND sg13cmos5l_decap_8
XFILLER_16_87 VPWR VGND sg13cmos5l_decap_8
XFILLER_16_94 VPWR VGND sg13cmos5l_decap_8
XFILLER_16_101 VPWR VGND sg13cmos5l_decap_8
XFILLER_16_108 VPWR VGND sg13cmos5l_decap_8
XFILLER_16_122 VPWR VGND sg13cmos5l_decap_4
XFILLER_16_134 VPWR VGND sg13cmos5l_decap_8
XFILLER_16_141 VPWR VGND sg13cmos5l_decap_8
XFILLER_16_148 VPWR VGND sg13cmos5l_decap_8
XFILLER_16_155 VPWR VGND sg13cmos5l_decap_8
XFILLER_16_175 VPWR VGND sg13cmos5l_decap_8
XFILLER_16_196 VPWR VGND sg13cmos5l_decap_8
XFILLER_16_203 VPWR VGND sg13cmos5l_decap_8
XFILLER_16_210 VPWR VGND sg13cmos5l_decap_8
XFILLER_16_217 VPWR VGND sg13cmos5l_decap_8
XFILLER_16_224 VPWR VGND sg13cmos5l_decap_8
XFILLER_17_9 VPWR VGND sg13cmos5l_decap_8
XFILLER_17_22 VPWR VGND sg13cmos5l_decap_8
XFILLER_17_29 VPWR VGND sg13cmos5l_decap_8
XFILLER_17_36 VPWR VGND sg13cmos5l_decap_4
XFILLER_17_47 VPWR VGND sg13cmos5l_decap_8
XFILLER_17_54 VPWR VGND sg13cmos5l_decap_4
XFILLER_17_64 VPWR VGND sg13cmos5l_decap_4
XFILLER_17_74 VPWR VGND sg13cmos5l_decap_8
XFILLER_17_92 VPWR VGND sg13cmos5l_decap_8
XFILLER_17_108 VPWR VGND sg13cmos5l_decap_8
XFILLER_17_115 VPWR VGND sg13cmos5l_decap_4
XFILLER_17_134 VPWR VGND sg13cmos5l_decap_8
XFILLER_17_150 VPWR VGND sg13cmos5l_decap_8
XFILLER_17_157 VPWR VGND sg13cmos5l_decap_8
XFILLER_17_175 VPWR VGND sg13cmos5l_decap_8
XFILLER_17_217 VPWR VGND sg13cmos5l_decap_8
XFILLER_17_224 VPWR VGND sg13cmos5l_decap_8
XFILLER_18_9 VPWR VGND sg13cmos5l_decap_8
XFILLER_18_31 VPWR VGND sg13cmos5l_decap_4
XFILLER_18_45 VPWR VGND sg13cmos5l_decap_8
XFILLER_18_52 VPWR VGND sg13cmos5l_decap_8
XFILLER_18_67 VPWR VGND sg13cmos5l_decap_4
XFILLER_18_92 VPWR VGND sg13cmos5l_decap_8
XFILLER_18_113 VPWR VGND sg13cmos5l_decap_8
XFILLER_18_120 VPWR VGND sg13cmos5l_decap_8
XFILLER_18_134 VPWR VGND sg13cmos5l_decap_8
XFILLER_18_150 VPWR VGND sg13cmos5l_decap_8
XFILLER_18_175 VPWR VGND sg13cmos5l_decap_8
XFILLER_18_211 VPWR VGND sg13cmos5l_decap_8
XFILLER_18_218 VPWR VGND sg13cmos5l_decap_8
XFILLER_18_225 VPWR VGND sg13cmos5l_decap_8
XFILLER_19_0 VPWR VGND sg13cmos5l_decap_4
XFILLER_19_9 VPWR VGND sg13cmos5l_decap_8
XFILLER_19_50 VPWR VGND sg13cmos5l_decap_8
XFILLER_19_92 VPWR VGND sg13cmos5l_decap_8
XFILLER_19_121 VPWR VGND sg13cmos5l_decap_8
XFILLER_19_134 VPWR VGND sg13cmos5l_decap_8
XFILLER_19_174 VPWR VGND sg13cmos5l_decap_8
XFILLER_19_181 VPWR VGND sg13cmos5l_decap_8
XFILLER_19_204 VPWR VGND sg13cmos5l_decap_8
XFILLER_19_211 VPWR VGND sg13cmos5l_decap_8
XFILLER_19_218 VPWR VGND sg13cmos5l_decap_8
XFILLER_19_225 VPWR VGND sg13cmos5l_decap_8
XFILLER_20_0 VPWR VGND sg13cmos5l_decap_8
XFILLER_20_7 VPWR VGND sg13cmos5l_decap_8
XFILLER_20_14 VPWR VGND sg13cmos5l_decap_8
XFILLER_20_21 VPWR VGND sg13cmos5l_decap_8
XFILLER_20_28 VPWR VGND sg13cmos5l_decap_8
XFILLER_20_35 VPWR VGND sg13cmos5l_decap_8
XFILLER_20_42 VPWR VGND sg13cmos5l_decap_8
XFILLER_20_49 VPWR VGND sg13cmos5l_decap_8
XFILLER_20_56 VPWR VGND sg13cmos5l_decap_4
XFILLER_20_69 VPWR VGND sg13cmos5l_decap_8
XFILLER_20_76 VPWR VGND sg13cmos5l_decap_8
XFILLER_20_90 VPWR VGND sg13cmos5l_decap_8
XFILLER_20_97 VPWR VGND sg13cmos5l_decap_8
XFILLER_20_104 VPWR VGND sg13cmos5l_decap_4
XFILLER_20_124 VPWR VGND sg13cmos5l_decap_8
XFILLER_20_131 VPWR VGND sg13cmos5l_decap_8
XFILLER_20_138 VPWR VGND sg13cmos5l_decap_4
XFILLER_20_156 VPWR VGND sg13cmos5l_decap_8
XFILLER_20_163 VPWR VGND sg13cmos5l_decap_8
XFILLER_20_170 VPWR VGND sg13cmos5l_decap_8
XFILLER_20_177 VPWR VGND sg13cmos5l_decap_8
XFILLER_20_184 VPWR VGND sg13cmos5l_decap_4
XFILLER_20_216 VPWR VGND sg13cmos5l_decap_8
XFILLER_20_223 VPWR VGND sg13cmos5l_decap_8
XFILLER_21_9 VPWR VGND sg13cmos5l_decap_8
XFILLER_21_22 VPWR VGND sg13cmos5l_decap_8
XFILLER_21_29 VPWR VGND sg13cmos5l_decap_8
XFILLER_21_36 VPWR VGND sg13cmos5l_decap_8
XFILLER_21_50 VPWR VGND sg13cmos5l_decap_8
XFILLER_21_69 VPWR VGND sg13cmos5l_decap_8
XFILLER_21_76 VPWR VGND sg13cmos5l_decap_4
XFILLER_21_92 VPWR VGND sg13cmos5l_decap_8
XFILLER_21_99 VPWR VGND sg13cmos5l_decap_4
XFILLER_21_131 VPWR VGND sg13cmos5l_decap_8
XFILLER_21_138 VPWR VGND sg13cmos5l_decap_4
XFILLER_21_152 VPWR VGND sg13cmos5l_decap_8
XFILLER_21_159 VPWR VGND sg13cmos5l_decap_8
XFILLER_21_166 VPWR VGND sg13cmos5l_decap_4
XFILLER_21_175 VPWR VGND sg13cmos5l_decap_8
XFILLER_21_211 VPWR VGND sg13cmos5l_decap_8
XFILLER_21_218 VPWR VGND sg13cmos5l_decap_8
XFILLER_21_225 VPWR VGND sg13cmos5l_decap_8
XFILLER_22_0 VPWR VGND sg13cmos5l_decap_4
XFILLER_22_9 VPWR VGND sg13cmos5l_decap_8
XFILLER_22_34 VPWR VGND sg13cmos5l_decap_8
XFILLER_22_50 VPWR VGND sg13cmos5l_decap_8
XFILLER_22_72 VPWR VGND sg13cmos5l_decap_8
XFILLER_22_92 VPWR VGND sg13cmos5l_decap_8
XFILLER_22_99 VPWR VGND sg13cmos5l_decap_8
XFILLER_22_106 VPWR VGND sg13cmos5l_decap_4
XFILLER_22_118 VPWR VGND sg13cmos5l_decap_8
XFILLER_22_134 VPWR VGND sg13cmos5l_decap_8
XFILLER_22_175 VPWR VGND sg13cmos5l_decap_8
XFILLER_22_195 VPWR VGND sg13cmos5l_decap_8
XFILLER_22_212 VPWR VGND sg13cmos5l_decap_8
XFILLER_22_219 VPWR VGND sg13cmos5l_decap_8
XFILLER_22_226 VPWR VGND sg13cmos5l_decap_8
XFILLER_23_0 VPWR VGND sg13cmos5l_decap_8
XFILLER_23_7 VPWR VGND sg13cmos5l_decap_8
XFILLER_23_49 VPWR VGND sg13cmos5l_decap_8
XFILLER_23_68 VPWR VGND sg13cmos5l_decap_8
XFILLER_23_79 VPWR VGND sg13cmos5l_decap_4
XFILLER_23_91 VPWR VGND sg13cmos5l_decap_8
XFILLER_23_113 VPWR VGND sg13cmos5l_decap_8
XFILLER_23_120 VPWR VGND sg13cmos5l_decap_8
XFILLER_23_127 VPWR VGND sg13cmos5l_decap_8
XFILLER_23_134 VPWR VGND sg13cmos5l_decap_8
XFILLER_23_152 VPWR VGND sg13cmos5l_decap_8
XFILLER_23_175 VPWR VGND sg13cmos5l_decap_8
XFILLER_23_217 VPWR VGND sg13cmos5l_decap_8
XFILLER_23_224 VPWR VGND sg13cmos5l_decap_8
XFILLER_24_0 VPWR VGND sg13cmos5l_decap_8
XFILLER_24_7 VPWR VGND sg13cmos5l_decap_8
XFILLER_24_14 VPWR VGND sg13cmos5l_decap_8
XFILLER_24_21 VPWR VGND sg13cmos5l_decap_8
XFILLER_24_34 VPWR VGND sg13cmos5l_decap_8
XFILLER_24_48 VPWR VGND sg13cmos5l_decap_8
XFILLER_24_55 VPWR VGND sg13cmos5l_decap_8
XFILLER_24_62 VPWR VGND sg13cmos5l_decap_8
XFILLER_24_92 VPWR VGND sg13cmos5l_decap_8
XFILLER_24_109 VPWR VGND sg13cmos5l_decap_4
XFILLER_24_127 VPWR VGND sg13cmos5l_decap_8
XFILLER_24_134 VPWR VGND sg13cmos5l_decap_8
XFILLER_24_165 VPWR VGND sg13cmos5l_decap_4
XFILLER_24_175 VPWR VGND sg13cmos5l_decap_8
XFILLER_24_188 VPWR VGND sg13cmos5l_decap_8
XFILLER_24_195 VPWR VGND sg13cmos5l_decap_4
XFILLER_24_213 VPWR VGND sg13cmos5l_decap_8
XFILLER_24_220 VPWR VGND sg13cmos5l_decap_8
XFILLER_24_227 VPWR VGND sg13cmos5l_decap_4
XFILLER_25_0 VPWR VGND sg13cmos5l_decap_8
XFILLER_25_7 VPWR VGND sg13cmos5l_decap_8
XFILLER_25_14 VPWR VGND sg13cmos5l_decap_8
XFILLER_25_21 VPWR VGND sg13cmos5l_decap_8
XFILLER_25_28 VPWR VGND sg13cmos5l_decap_8
XFILLER_25_35 VPWR VGND sg13cmos5l_decap_8
XFILLER_25_42 VPWR VGND sg13cmos5l_decap_8
XFILLER_25_49 VPWR VGND sg13cmos5l_decap_8
XFILLER_25_91 VPWR VGND sg13cmos5l_decap_8
XFILLER_25_134 VPWR VGND sg13cmos5l_decap_8
XFILLER_25_141 VPWR VGND sg13cmos5l_decap_4
XFILLER_25_175 VPWR VGND sg13cmos5l_decap_8
XFILLER_25_192 VPWR VGND sg13cmos5l_decap_8
XFILLER_25_205 VPWR VGND sg13cmos5l_decap_8
XFILLER_25_212 VPWR VGND sg13cmos5l_decap_8
XFILLER_25_219 VPWR VGND sg13cmos5l_decap_8
XFILLER_25_226 VPWR VGND sg13cmos5l_decap_8
XFILLER_26_0 VPWR VGND sg13cmos5l_decap_8
XFILLER_26_7 VPWR VGND sg13cmos5l_decap_8
XFILLER_26_14 VPWR VGND sg13cmos5l_decap_8
XFILLER_26_21 VPWR VGND sg13cmos5l_decap_8
XFILLER_26_28 VPWR VGND sg13cmos5l_decap_8
XFILLER_26_35 VPWR VGND sg13cmos5l_decap_4
XFILLER_26_50 VPWR VGND sg13cmos5l_decap_8
XFILLER_26_86 VPWR VGND sg13cmos5l_decap_8
XFILLER_26_93 VPWR VGND sg13cmos5l_decap_8
XFILLER_26_130 VPWR VGND sg13cmos5l_decap_8
XFILLER_26_137 VPWR VGND sg13cmos5l_decap_4
XFILLER_26_175 VPWR VGND sg13cmos5l_decap_8
XFILLER_26_203 VPWR VGND sg13cmos5l_decap_4
XFILLER_26_212 VPWR VGND sg13cmos5l_decap_8
XFILLER_26_219 VPWR VGND sg13cmos5l_decap_8
XFILLER_26_226 VPWR VGND sg13cmos5l_decap_8
XFILLER_27_0 VPWR VGND sg13cmos5l_decap_8
XFILLER_27_7 VPWR VGND sg13cmos5l_decap_8
XFILLER_27_14 VPWR VGND sg13cmos5l_decap_8
XFILLER_27_50 VPWR VGND sg13cmos5l_decap_8
XFILLER_27_57 VPWR VGND sg13cmos5l_decap_4
XFILLER_27_92 VPWR VGND sg13cmos5l_decap_8
XFILLER_27_99 VPWR VGND sg13cmos5l_decap_8
XFILLER_27_134 VPWR VGND sg13cmos5l_decap_8
XFILLER_27_169 VPWR VGND sg13cmos5l_decap_8
XFILLER_27_176 VPWR VGND sg13cmos5l_decap_8
XFILLER_27_183 VPWR VGND sg13cmos5l_decap_8
XFILLER_27_217 VPWR VGND sg13cmos5l_decap_8
XFILLER_27_224 VPWR VGND sg13cmos5l_decap_8
XFILLER_28_0 VPWR VGND sg13cmos5l_decap_4
XFILLER_28_9 VPWR VGND sg13cmos5l_decap_8
XFILLER_28_16 VPWR VGND sg13cmos5l_decap_8
XFILLER_28_23 VPWR VGND sg13cmos5l_decap_4
XFILLER_28_31 VPWR VGND sg13cmos5l_decap_8
XFILLER_28_47 VPWR VGND sg13cmos5l_decap_8
XFILLER_28_54 VPWR VGND sg13cmos5l_decap_4
XFILLER_28_63 VPWR VGND sg13cmos5l_decap_8
XFILLER_28_70 VPWR VGND sg13cmos5l_decap_4
XFILLER_28_79 VPWR VGND sg13cmos5l_decap_8
XFILLER_28_92 VPWR VGND sg13cmos5l_decap_8
XFILLER_28_99 VPWR VGND sg13cmos5l_decap_8
XFILLER_28_111 VPWR VGND sg13cmos5l_decap_8
XFILLER_28_118 VPWR VGND sg13cmos5l_decap_4
XFILLER_28_127 VPWR VGND sg13cmos5l_decap_8
XFILLER_28_134 VPWR VGND sg13cmos5l_decap_8
XFILLER_28_150 VPWR VGND sg13cmos5l_decap_4
XFILLER_28_159 VPWR VGND sg13cmos5l_decap_8
XFILLER_28_166 VPWR VGND sg13cmos5l_decap_4
XFILLER_28_175 VPWR VGND sg13cmos5l_decap_8
XFILLER_28_182 VPWR VGND sg13cmos5l_decap_4
XFILLER_28_191 VPWR VGND sg13cmos5l_decap_8
XFILLER_28_198 VPWR VGND sg13cmos5l_decap_4
XFILLER_28_207 VPWR VGND sg13cmos5l_decap_4
XFILLER_28_217 VPWR VGND sg13cmos5l_decap_8
XFILLER_28_224 VPWR VGND sg13cmos5l_decap_4
.ENDS lock_ctrl

* ===== /home/michael/Documents/Passionate/custom_stdcell/custom_stdcell.cdl
************************************************************************
* Library Name: custom_stdcell
* Cell Name:    custom_einvn_1
* View Name:    schematic
************************************************************************

.SUBCKT custom_einvn_1 Z A TE_B VDD VSS
*.PININFO A:I TE_B:I Z:O VDD:B VSS:B
MN0 TE TE_B VSS VSS sg13_lv_nmos m=1 w=420.00n l=130.00n ng=1
MN2 net1 TE VSS VSS sg13_lv_nmos m=1 w=0.74u l=130.00n ng=1
MN1 Z A net1 VSS sg13_lv_nmos m=1 w=0.74u l=130.00n ng=1
MP0 TE TE_B VDD VDD sg13_lv_pmos m=1 w=640.00n l=130.00n ng=1
MP1 net2 TE_B VDD VDD sg13_lv_pmos m=1 w=1.12u l=130.00n ng=1
MP2 Z A net2 VDD sg13_lv_pmos m=1 w=1.12u l=130.00n ng=1
.ENDS

************************************************************************
* Library Name: custom_stdcell
* Cell Name:    custom_einvn_16
* View Name:    schematic
************************************************************************

.SUBCKT custom_einvn_16 Z A TE_B VDD VSS
*.PININFO A:I TE_B:I Z:O VDD:B VSS:B
MN1 Z A net29 VSS sg13_lv_nmos m=1 w=11.84u l=130.00n ng=16
MN0 TE TE_B VSS VSS sg13_lv_nmos m=1 w=740.00n l=130.00n ng=1
MN2 net29 TE VSS VSS sg13_lv_nmos m=1 w=11.84u l=130.00n ng=16
MP1 net28 TE_B VDD VDD sg13_lv_pmos m=1 w=17.92u l=130.00n ng=16
MP2 Z A net28 VDD sg13_lv_pmos m=1 w=17.92u l=130.00n ng=16
MP0 TE TE_B VDD VDD sg13_lv_pmos m=1 w=1.12u l=130.00n ng=1
.ENDS

.SUBCKT custom_einvn_p5 Z A TE_B VDD VSS
*.PININFO A:I TE_B:I Z:O VDD:B VSS:B
MN0 TE TE_B VSS VSS sg13_lv_nmos m=1 w=420.00n l=130.00n ng=1
MN2 net1 TE VSS VSS sg13_lv_nmos m=1 w=0.37u l=130.00n ng=1
MN1 Z A net1 VSS sg13_lv_nmos m=1 w=0.37u l=130.00n ng=1
MP0 TE TE_B VDD VDD sg13_lv_pmos m=1 w=640.00n l=130.00n ng=1
MP1 net2 TE_B VDD VDD sg13_lv_pmos m=1 w=0.56u l=130.00n ng=1
MP2 Z A net2 VDD sg13_lv_pmos m=1 w=0.56u l=130.00n ng=1
.ENDS

.SUBCKT custom_cap_16 C A VDD VSS
M1 A C net2 VSS sg13_lv_nmos w=1.48u l=0.13u ng=2 m=1
M2 net1 C VDD VDD sg13_lv_pmos w=1.12u l=0.13u ng=1 m=1
M3 net2 net1 A VDD sg13_lv_pmos w=2.24u l=0.13u ng=2 m=1
M4 net1 C VSS VSS sg13_lv_nmos w=0.74u l=0.13u ng=1 m=1
M5 VDD net2 VDD VDD sg13_lv_pmos w=1.12u l=3.42u ng=1 m=1
M6 VSS net2 VSS VSS sg13_lv_nmos w=0.74u l=3.42u ng=1 m=1
.ENDS

.SUBCKT custom_cap_8 C A VDD VSS
M1 A C net2 VSS sg13_lv_nmos w=1.11u l=0.13u ng=1 m=1
M2 net1 C VDD VDD sg13_lv_pmos w=1.12u l=0.13u ng=1 m=1
M3 net2 net1 A VDD sg13_lv_pmos w=1.68u l=0.13u ng=2 m=1
M4 net1 C VSS VSS sg13_lv_nmos w=0.74u l=0.13u ng=1 m=1
M5 VDD net2 VDD VDD sg13_lv_pmos w=1.12u l=1.62u ng=1 m=1
M6 VSS net2 VSS VSS sg13_lv_nmos w=0.74u l=1.62u ng=1 m=1
.ENDS

.SUBCKT custom_cap_4 C A VDD VSS
M1 A C net2 VSS sg13_lv_nmos w=0.78u l=0.13u ng=1 m=1
M2 net1 C VDD VDD sg13_lv_pmos w=1.12u l=0.13u ng=1 m=1
M3 net2 net1 A VDD sg13_lv_pmos w=1.19u l=0.13u ng=1 m=1
M4 net1 C VSS VSS sg13_lv_nmos w=0.74u l=0.13u ng=1 m=1
M5 VDD net2 VDD VDD sg13_lv_pmos w=1.12u l=0.74u ng=1 m=1
M6 VSS net2 VSS VSS sg13_lv_nmos w=0.755u l=0.74u ng=1 m=1
.ENDS

.SUBCKT custom_cap_2 C A VDD VSS
M1 A C net2 VSS sg13_lv_nmos w=0.53u l=0.13u ng=1 m=1
M2 net1 C VDD VDD sg13_lv_pmos w=1.12u l=0.13u ng=1 m=1
M3 net2 net1 A VDD sg13_lv_pmos w=0.82u l=0.13u ng=1 m=1
M4 net1 C VSS VSS sg13_lv_nmos w=0.74u l=0.13u ng=1 m=1
M5 VDD net2 VDD VDD sg13_lv_pmos w=1.13u l=0.32u ng=1 m=1
M6 VSS net2 VSS VSS sg13_lv_nmos w=0.77u l=0.32u ng=1 m=1
.ENDS

.SUBCKT custom_cap_1 C A VDD VSS
M1 A C net2 VSS sg13_lv_nmos w=0.36u l=0.13u ng=1 m=1
M2 net1 C VDD VDD sg13_lv_pmos w=1.12u l=0.13u ng=1 m=1
M3 net2 net1 A VDD sg13_lv_pmos w=0.55u l=0.13u ng=1 m=1
M4 net1 C VSS VSS sg13_lv_nmos w=0.74u l=0.13u ng=1 m=1
M5 VDD net2 VDD VDD sg13_lv_pmos w=1.12u l=0.13u ng=1 m=1
M6 VSS net2 VSS VSS sg13_lv_nmos w=0.74u l=0.13u ng=1 m=1
.ENDS

.SUBCKT custom_cap_p5 C A VDD VSS
M1 A C net2 VSS sg13_lv_nmos w=0.30u l=0.13u ng=1 m=1
M2 net1 C VDD VDD sg13_lv_pmos w=1.12u l=0.13u ng=1 m=1
M3 net2 net1 A VDD sg13_lv_pmos w=0.30u l=0.13u ng=1 m=1
M4 net1 C VSS VSS sg13_lv_nmos w=0.74u l=0.13u ng=1 m=1
M5 VDD net2 VDD VDD sg13_lv_pmos w=0.495u l=0.13u ng=1 m=1
M6 VSS net2 VSS VSS sg13_lv_nmos w=0.30u l=0.13u ng=1 m=1
.ENDS

.SUBCKT custom_cap_p25 C A VDD VSS
M1 A C net2 VSS sg13_lv_nmos w=0.15u l=0.13u ng=1 m=1
M2 net1 C VDD VDD sg13_lv_pmos w=1.12u l=0.13u ng=1 m=1
M3 net2 net1 A VDD sg13_lv_pmos w=0.30u l=0.13u ng=1 m=1
M4 net1 C VSS VSS sg13_lv_nmos w=0.74u l=0.13u ng=1 m=1
M5 VSS net2 VSS VDD sg13_lv_pmos w=0.15u l=0.13u ng=1 m=1
M6 VDD net2 VDD VSS sg13_lv_nmos w=0.15u l=0.13u ng=1 m=1
.ENDS

.SUBCKT custom_cap_p125 C A VDD VSS
M1 net2 C A VSS sg13_lv_nmos w=0.18u l=0.13u ng=1 m=1
M2 net1 C VDD VDD sg13_lv_pmos w=1.12u l=0.13u ng=1 m=1
M3 net3 net1 A VDD sg13_lv_pmos w=0.15u l=0.13u ng=1 m=1
M4 net1 C VSS VSS sg13_lv_nmos w=0.74u l=0.13u ng=1 m=1
.ENDS

* ===== /opt/IHP-Open-PDK/ihp-sg13cmos5l/libs.ref/sg13cmos5l_stdcell/cdl/sg13cmos5l_stdcell.cdl
************************************************************************
*
* Copyright 2023 IHP PDK Authors
*
* Licensed under the Apache License, Version 2.0 (the "License");
* you may not use this file except in compliance with the License.
* You may obtain a copy of the License at
*
*    https://www.apache.org/licenses/LICENSE-2.0
*
* Unless required by applicable law or agreed to in writing, software
* distributed under the License is distributed on an "AS IS" BASIS,
* WITHOUT WARRANTIES OR CONDITIONS OF ANY KIND, either express or implied.
* See the License for the specific language governing permissions and
* limitations under the License.
*
************************************************************************

************************************************************************
* Library Name: sg13cmos5l_stdcell
* Cell Name:    sg13cmos5l_a21o_1
* View Name:    schematic
************************************************************************

.SUBCKT sg13cmos5l_a21o_1 X A1 A2 B1 VDD VSS
*.PININFO A1:I A2:I B1:I X:O VDD:B VSS:B
MN0 net1 A1 net2 VSS sg13_lv_nmos m=1 w=640.00n l=130.00n ng=1
MN1 net2 A2 VSS VSS sg13_lv_nmos m=1 w=640.00n l=130.00n ng=1
MN2 net1 B1 VSS VSS sg13_lv_nmos m=1 w=640.00n l=130.00n ng=1
MN3 X net1 VSS VSS sg13_lv_nmos m=1 w=740.00n l=130.00n ng=1
MP2 net1 B1 net3 VDD sg13_lv_pmos m=1 w=1.000u l=130.00n ng=1
MP0 net3 A1 VDD VDD sg13_lv_pmos m=1 w=1.000u l=130.00n ng=1
MP1 net3 A2 VDD VDD sg13_lv_pmos m=1 w=1.000u l=130.00n ng=1
MP3 X net1 VDD VDD sg13_lv_pmos m=1 w=1.12u l=130.00n ng=1
.ENDS

************************************************************************
* Library Name: sg13cmos5l_stdcell
* Cell Name:    sg13cmos5l_a21o_2
* View Name:    schematic
************************************************************************

.SUBCKT sg13cmos5l_a21o_2 X A1 A2 B1 VDD VSS
*.PININFO A1:I A2:I B1:I X:O VDD:B VSS:B
MN0 net1 A1 net2 VSS sg13_lv_nmos m=1 w=740.00n l=130.00n ng=1
MN1 net2 A2 VSS VSS sg13_lv_nmos m=1 w=740.00n l=130.00n ng=1
MN2 net1 B1 VSS VSS sg13_lv_nmos m=1 w=740.00n l=130.00n ng=1
MN3 X net1 VSS VSS sg13_lv_nmos m=1 w=1.48u l=130.00n ng=2
MP2 net1 B1 net3 VDD sg13_lv_pmos m=1 w=1.000u l=130.00n ng=1
MP0 net3 A1 VDD VDD sg13_lv_pmos m=1 w=1.000u l=130.00n ng=1
MP1 net3 A2 VDD VDD sg13_lv_pmos m=1 w=1.000u l=130.00n ng=1
MP3 X net1 VDD VDD sg13_lv_pmos m=1 w=2.24u l=130.00n ng=2
.ENDS

************************************************************************
* Library Name: sg13cmos5l_stdcell
* Cell Name:    sg13cmos5l_a21oi_1
* View Name:    schematic
************************************************************************

.SUBCKT sg13cmos5l_a21oi_1 Y A1 A2 B1 VDD VSS
*.PININFO A1:I A2:I B1:I Y:O VDD:B VSS:B
MN0 Y B1 VSS VSS sg13_lv_nmos m=1 w=740.00n l=130.00n ng=1
MN2 net1 A2 VSS VSS sg13_lv_nmos m=1 w=740.00n l=130.00n ng=1
MN1 Y A1 net1 VSS sg13_lv_nmos m=1 w=740.00n l=130.00n ng=1
MP2 Y B1 net2 VDD sg13_lv_pmos m=1 w=1.12u l=130.00n ng=1
MP1 net2 A2 VDD VDD sg13_lv_pmos m=1 w=1.12u l=130.00n ng=1
MP0 net2 A1 VDD VDD sg13_lv_pmos m=1 w=1.12u l=130.00n ng=1
.ENDS

************************************************************************
* Library Name: sg13cmos5l_stdcell
* Cell Name:    sg13cmos5l_a21oi_2
* View Name:    schematic
************************************************************************

.SUBCKT sg13cmos5l_a21oi_2 Y A1 A2 B1 VDD VSS
*.PININFO A1:I A2:I B1:I Y:O VDD:B VSS:B
MN0 Y B1 VSS VSS sg13_lv_nmos m=1 w=1.48u l=130.00n ng=2
MN2 net2 A2 VSS VSS sg13_lv_nmos m=1 w=1.48u l=130.00n ng=2
MN1 Y A1 net2 VSS sg13_lv_nmos m=1 w=1.48u l=130.00n ng=2
MP2 Y B1 net1 VDD sg13_lv_pmos m=1 w=2.24u l=130.00n ng=2
MP1 net1 A2 VDD VDD sg13_lv_pmos m=1 w=2.24u l=130.00n ng=2
MP0 net1 A1 VDD VDD sg13_lv_pmos m=1 w=2.24u l=130.00n ng=2
.ENDS

************************************************************************
* Library Name: sg13cmos5l_stdcell
* Cell Name:    sg13cmos5l_a221oi_1
* View Name:    schematic
************************************************************************

.SUBCKT sg13cmos5l_a221oi_1 Y A1 A2 B1 B2 C1 VDD VSS
*.PININFO A1:I A2:I B1:I B2:I C1:I Y:O VDD:B VSS:B
MP2 Y C1 net3 VDD sg13_lv_pmos m=1 w=1.12u l=130.00n ng=1
MP4 net3 B2 net1 VDD sg13_lv_pmos m=1 w=1.12u l=130.00n ng=1
MP1 net3 B1 net1 VDD sg13_lv_pmos m=1 w=1.12u l=130.00n ng=1
MP3 net1 A2 VDD VDD sg13_lv_pmos m=1 w=1.12u l=130.00n ng=1
MP0 net1 A1 VDD VDD sg13_lv_pmos m=1 w=1.12u l=130.00n ng=1
MN4 Y C1 VSS VSS sg13_lv_nmos m=1 w=740.00n l=130.00n ng=1
MN3 net4 B2 VSS VSS sg13_lv_nmos m=1 w=740.00n l=130.00n ng=1
MN2 Y B1 net4 VSS sg13_lv_nmos m=1 w=740.00n l=130.00n ng=1
MN1 net2 A2 VSS VSS sg13_lv_nmos m=1 w=740.00n l=130.00n ng=1
MN0 Y A1 net2 VSS sg13_lv_nmos m=1 w=740.00n l=130.00n ng=1
.ENDS

************************************************************************
* Library Name: sg13cmos5l_stdcell
* Cell Name:    sg13cmos5l_and2_1
* View Name:    schematic
************************************************************************

.SUBCKT sg13cmos5l_and2_1 X A B VDD VSS
*.PININFO A:I B:I X:O VDD:B VSS:B
MN0 net4 A net2 VSS sg13_lv_nmos m=1 w=640.00n l=130.00n ng=1
MN2 X net4 VSS VSS sg13_lv_nmos m=1 w=740.00n l=130.00n ng=1
MN1 net2 B VSS VSS sg13_lv_nmos m=1 w=640.00n l=130.00n ng=1
MP0 net4 B VDD VDD sg13_lv_pmos m=1 w=840.00n l=130.00n ng=1
MP2 X net4 VDD VDD sg13_lv_pmos m=1 w=1.12u l=130.00n ng=1
MP1 net4 A VDD VDD sg13_lv_pmos m=1 w=840.00n l=130.00n ng=1
.ENDS

************************************************************************
* Library Name: sg13cmos5l_stdcell
* Cell Name:    sg13cmos5l_and2_2
* View Name:    schematic
************************************************************************

.SUBCKT sg13cmos5l_and2_2 X A B VDD VSS
*.PININFO A:I B:I X:O VDD:B VSS:B
MN0 net1 A net2 VSS sg13_lv_nmos m=1 w=640.00n l=130.00n ng=1
MN2 X net1 VSS VSS sg13_lv_nmos m=1 w=1.48u l=130.00n ng=2
MN1 net2 B VSS VSS sg13_lv_nmos m=1 w=640.00n l=130.00n ng=1
MP0 net1 B VDD VDD sg13_lv_pmos m=1 w=840.00n l=130.00n ng=1
MP2 X net1 VDD VDD sg13_lv_pmos m=1 w=2.24u l=130.00n ng=2
MP1 net1 A VDD VDD sg13_lv_pmos m=1 w=840.00n l=130.00n ng=1
.ENDS

************************************************************************
* Library Name: sg13cmos5l_stdcell
* Cell Name:    sg13cmos5l_and3_1
* View Name:    schematic
************************************************************************

.SUBCKT sg13cmos5l_and3_1 X A B C VDD VSS
*.PININFO A:I B:I C:I X:O VDD:B VSS:B
MN2 net3 C VSS VSS sg13_lv_nmos m=1 w=640.00n l=130.00n ng=1
MN3 X net2 VSS VSS sg13_lv_nmos m=1 w=740.00n l=130.00n ng=1
MN0 net2 A net1 VSS sg13_lv_nmos m=1 w=640.00n l=130.00n ng=1
MN1 net1 B net3 VSS sg13_lv_nmos m=1 w=640.00n l=130.00n ng=1
MP3 X net2 VDD VDD sg13_lv_pmos m=1 w=1.12u l=130.00n ng=1
MP1 net2 B VDD VDD sg13_lv_pmos m=1 w=840.00n l=130.00n ng=1
MP2 net2 A VDD VDD sg13_lv_pmos m=1 w=840.00n l=130.00n ng=1
MP0 net2 C VDD VDD sg13_lv_pmos m=1 w=840.00n l=130.00n ng=1
.ENDS

************************************************************************
* Library Name: sg13cmos5l_stdcell
* Cell Name:    sg13cmos5l_and3_2
* View Name:    schematic
************************************************************************

.SUBCKT sg13cmos5l_and3_2 X A B C VDD VSS
*.PININFO A:I B:I C:I X:O VDD:B VSS:B
MN2 net3 C VSS VSS sg13_lv_nmos m=1 w=640.00n l=130.00n ng=1
MN3 X net2 VSS VSS sg13_lv_nmos m=1 w=1.48u l=130.00n ng=2
MN0 net2 A net1 VSS sg13_lv_nmos m=1 w=640.00n l=130.00n ng=1
MN1 net1 B net3 VSS sg13_lv_nmos m=1 w=640.00n l=130.00n ng=1
MP3 X net2 VDD VDD sg13_lv_pmos m=1 w=2.24u l=130.00n ng=2
MP1 net2 B VDD VDD sg13_lv_pmos m=1 w=840.00n l=130.00n ng=1
MP2 net2 A VDD VDD sg13_lv_pmos m=1 w=840.00n l=130.00n ng=1
MP0 net2 C VDD VDD sg13_lv_pmos m=1 w=840.00n l=130.00n ng=1
.ENDS

************************************************************************
* Library Name: sg13cmos5l_stdcell
* Cell Name:    sg13cmos5l_and4_1
* View Name:    schematic
************************************************************************

.SUBCKT sg13cmos5l_and4_1 X A B C D VDD VSS
*.PININFO A:I B:I C:I D:I X:O VDD:B VSS:B
MN3 net17 D VSS VSS sg13_lv_nmos m=1 w=640.00n l=130.00n ng=1
MN2 net16 C net17 VSS sg13_lv_nmos m=1 w=640.00n l=130.00n ng=1
MN1 net15 B net16 VSS sg13_lv_nmos m=1 w=640.00n l=130.00n ng=1
MN0 net1 A net15 VSS sg13_lv_nmos m=1 w=640.00n l=130.00n ng=1
MN4 X net1 VSS VSS sg13_lv_nmos m=1 w=740.00n l=130.00n ng=1
MP3 net1 A VDD VDD sg13_lv_pmos m=1 w=840.00n l=130.00n ng=1
MP4 X net1 VDD VDD sg13_lv_pmos m=1 w=1.12u l=130.00n ng=1
MP0 net1 D VDD VDD sg13_lv_pmos m=1 w=840.00n l=130.00n ng=1
MP1 net1 C VDD VDD sg13_lv_pmos m=1 w=840.00n l=130.00n ng=1
MP2 net1 B VDD VDD sg13_lv_pmos m=1 w=840.00n l=130.00n ng=1
.ENDS

************************************************************************
* Library Name: sg13cmos5l_stdcell
* Cell Name:    sg13cmos5l_and4_2
* View Name:    schematic
************************************************************************

.SUBCKT sg13cmos5l_and4_2 X A B C D VDD VSS
*.PININFO A:I B:I C:I D:I X:O VDD:B VSS:B
MN3 net17 D VSS VSS sg13_lv_nmos m=1 w=640.00n l=130.00n ng=1
MN2 net16 C net17 VSS sg13_lv_nmos m=1 w=640.00n l=130.00n ng=1
MN1 net15 B net16 VSS sg13_lv_nmos m=1 w=640.00n l=130.00n ng=1
MN0 net1 A net15 VSS sg13_lv_nmos m=1 w=640.00n l=130.00n ng=1
MN4 X net1 VSS VSS sg13_lv_nmos m=1 w=1.48u l=130.00n ng=2
MP3 net1 A VDD VDD sg13_lv_pmos m=1 w=840.00n l=130.00n ng=1
MP4 X net1 VDD VDD sg13_lv_pmos m=1 w=2.24u l=130.00n ng=2
MP0 net1 D VDD VDD sg13_lv_pmos m=1 w=840.00n l=130.00n ng=1
MP1 net1 C VDD VDD sg13_lv_pmos m=1 w=840.00n l=130.00n ng=1
MP2 net1 B VDD VDD sg13_lv_pmos m=1 w=840.00n l=130.00n ng=1
.ENDS

************************************************************************
* Library Name: sg13cmos5l_stdcell
* Cell Name:    sg13cmos5l_antennanp
* View Name:    schematic
************************************************************************

.SUBCKT sg13cmos5l_antennanp A VDD VSS
*.PININFO A:I VDD:B VSS:B
DD1 VSS A dantenna m=1 w=780n l=780n a=608.4f p=3.12u
DD0 A VDD dpantenna m=1 w=1.05u l=1.34u a=1.407p p=4.78u
.ENDS

************************************************************************
* Library Name: sg13cmos5l_stdcell
* Cell Name:    sg13cmos5l_buf_1
* View Name:    schematic
************************************************************************

.SUBCKT sg13cmos5l_buf_1 X A VDD VSS
*.PININFO A:I X:O VDD:B VSS:B
MN0 net1 A VSS VSS sg13_lv_nmos m=1 w=550.00n l=130.00n ng=1
MN1 X net1 VSS VSS sg13_lv_nmos m=1 w=740.00n l=130.00n ng=1
MP1 X net1 VDD VDD sg13_lv_pmos m=1 w=1.12u l=130.00n ng=1
MP0 net1 A VDD VDD sg13_lv_pmos m=1 w=840.00n l=130.00n ng=1
.ENDS

************************************************************************
* Library Name: sg13cmos5l_stdcell
* Cell Name:    sg13cmos5l_buf_16
* View Name:    schematic
************************************************************************

.SUBCKT sg13cmos5l_buf_16 X A VDD VSS
*.PININFO A:I X:O VDD:B VSS:B
MN0 net1 A VSS VSS sg13_lv_nmos m=1 w=4.44u l=130.00n ng=6
MN1 X net1 VSS VSS sg13_lv_nmos m=1 w=11.84u l=130.00n ng=16
MP1 X net1 VDD VDD sg13_lv_pmos m=1 w=17.92u l=130.00n ng=16
MP0 net1 A VDD VDD sg13_lv_pmos m=1 w=6.72u l=130.00n ng=6
.ENDS

************************************************************************
* Library Name: sg13cmos5l_stdcell
* Cell Name:    sg13cmos5l_buf_2
* View Name:    schematic
************************************************************************

.SUBCKT sg13cmos5l_buf_2 X A VDD VSS
*.PININFO A:I X:O VDD:B VSS:B
MN0 net1 A VSS VSS sg13_lv_nmos m=1 w=640.00n l=130.00n ng=1
MN1 X net1 VSS VSS sg13_lv_nmos m=1 w=1.48u l=130.00n ng=2
MP1 X net1 VDD VDD sg13_lv_pmos m=1 w=2.24u l=130.00n ng=2
MP0 net1 A VDD VDD sg13_lv_pmos m=1 w=1.000u l=130.00n ng=1
.ENDS

************************************************************************
* Library Name: sg13cmos5l_stdcell
* Cell Name:    sg13cmos5l_buf_4
* View Name:    schematic
************************************************************************

.SUBCKT sg13cmos5l_buf_4 X A VDD VSS
*.PININFO A:I X:O VDD:B VSS:B
MN0 net1 A VSS VSS sg13_lv_nmos m=1 w=740.00n l=130.00n ng=1
MN1 X net1 VSS VSS sg13_lv_nmos m=1 w=2.96u l=130.00n ng=4
MP1 X net1 VDD VDD sg13_lv_pmos m=1 w=4.48u l=130.00n ng=4
MP0 net1 A VDD VDD sg13_lv_pmos m=1 w=1.68u l=130.00n ng=2
.ENDS

************************************************************************
* Library Name: sg13cmos5l_stdcell
* Cell Name:    sg13cmos5l_buf_8
* View Name:    schematic
************************************************************************

.SUBCKT sg13cmos5l_buf_8 X A VDD VSS
*.PININFO A:I X:O VDD:B VSS:B
MN0 net1 A VSS VSS sg13_lv_nmos m=1 w=2.22u l=130.00n ng=3
MN1 X net1 VSS VSS sg13_lv_nmos m=1 w=5.92u l=130.00n ng=8
MP1 X net1 VDD VDD sg13_lv_pmos m=1 w=8.96u l=130.00n ng=8
MP0 net1 A VDD VDD sg13_lv_pmos m=1 w=3.36u l=130.00n ng=3
.ENDS

************************************************************************
* Library Name: sg13cmos5l_stdcell
* Cell Name:    sg13cmos5l_decap_4
* View Name:    schematic
************************************************************************

.SUBCKT sg13cmos5l_decap_4 VDD VSS
*.PININFO VDD:B VSS:B
MN0 VSS VDD VSS VSS sg13_lv_nmos m=1 w=420.00n l=1.000u ng=1
MP0 VDD VSS VDD VDD sg13_lv_pmos m=1 w=1.000u l=1.000u ng=1
.ENDS

************************************************************************
* Library Name: sg13cmos5l_stdcell
* Cell Name:    sg13cmos5l_decap_8
* View Name:    schematic
************************************************************************

.SUBCKT sg13cmos5l_decap_8 VDD VSS
*.PININFO VDD:B VSS:B
MN0 VSS VDD VSS VSS sg13_lv_nmos m=1 w=840.00n l=1.000u ng=2
MP0 VDD VSS VDD VDD sg13_lv_pmos m=1 w=2.000u l=1.000u ng=2
.ENDS

************************************************************************
* Library Name: sg13cmos5l_stdcell
* Cell Name:    sg13cmos5l_dfrbp_1
* View Name:    schematic
************************************************************************

.SUBCKT sg13cmos5l_dfrbp_1 Q Q_N CLK D RESET_B VDD VSS
*.PININFO CLK:I D:I RESET_B:I Q:O Q_N:O VDD:B VSS:B
MN11 net12 net2 VSS VSS sg13_lv_nmos m=1 w=420.00n l=130.00n ng=1
MN10 net5 clkneg net12 VSS sg13_lv_nmos m=1 w=420.00n l=130.00n ng=1
MN12 net2 net5 net11 VSS sg13_lv_nmos m=1 w=420.00n l=130.00n ng=1
MN13 net11 RESET_B VSS VSS sg13_lv_nmos m=1 w=420.00n l=130.00n ng=1
MN14 Q_N net5 VSS VSS sg13_lv_nmos m=1 w=740.00n l=130.00n ng=1
MN0 Db D net10 VSS sg13_lv_nmos m=1 w=420.00n l=130.00n ng=1
MN1 net10 RESET_B VSS VSS sg13_lv_nmos m=1 w=420.00n l=130.00n ng=1
MN4 Db clkneg net6 VSS sg13_lv_nmos m=1 w=420.00n l=130.00n ng=1
MN5 net6 clkpos net9 VSS sg13_lv_nmos m=1 w=420.00n l=130.00n ng=1
MN6 net9 net4 net8 VSS sg13_lv_nmos m=1 w=420.00n l=130.00n ng=1
MN7 net8 RESET_B VSS VSS sg13_lv_nmos m=1 w=420.00n l=130.00n ng=1
MN8 net4 net6 VSS VSS sg13_lv_nmos m=1 w=740.00n l=130.00n ng=1
MN2 clkneg CLK VSS VSS sg13_lv_nmos m=1 w=740.00n l=130.00n ng=1
MN9 net4 clkpos net5 VSS sg13_lv_nmos m=1 w=740.00n l=130.00n ng=1
MN3 clkpos clkneg VSS VSS sg13_lv_nmos m=1 w=740.00n l=130.00n ng=1
MN16 Q net1 VSS VSS sg13_lv_nmos m=1 w=740.00n l=130.00n ng=1
MN15 net1 net5 VSS VSS sg13_lv_nmos m=1 w=740.00n l=130.00n ng=1
MP11 net5 clkpos net3 VDD sg13_lv_pmos m=1 w=420.00n l=130.00n ng=1
MP12 net2 net5 VDD VDD sg13_lv_pmos m=1 w=420.00n l=130.00n ng=1
MP13 net2 RESET_B VDD VDD sg13_lv_pmos m=1 w=420.00n l=130.00n ng=1
MP14 Q_N net5 VDD VDD sg13_lv_pmos m=1 w=1.12u l=130.00n ng=1
MP4 Db clkpos net6 VDD sg13_lv_pmos m=1 w=420.00n l=130.00n ng=1
MP0 Db RESET_B VDD VDD sg13_lv_pmos m=1 w=420.00n l=130.00n ng=1
MP1 Db D VDD VDD sg13_lv_pmos m=1 w=420.00n l=130.00n ng=1
MP5 net7 net4 VDD VDD sg13_lv_pmos m=1 w=420.00n l=130.00n ng=1
MP6 net6 clkneg net7 VDD sg13_lv_pmos m=1 w=420.00n l=130.00n ng=1
MP7 net6 RESET_B VDD VDD sg13_lv_pmos m=1 w=420.00n l=130.00n ng=1
MP2 clkneg CLK VDD VDD sg13_lv_pmos m=1 w=1.12u l=130.00n ng=1
MP3 clkpos clkneg VDD VDD sg13_lv_pmos m=1 w=1.12u l=130.00n ng=1
MP8 net4 net6 VDD VDD sg13_lv_pmos m=1 w=1.000u l=130.00n ng=1
MP9 net4 clkneg net5 VDD sg13_lv_pmos m=1 w=1.000u l=130.00n ng=1
MP16 Q net1 VDD VDD sg13_lv_pmos m=1 w=1.12u l=130.00n ng=1
MP10 net3 net2 VDD VDD sg13_lv_pmos m=1 w=420.00n l=130.00n ng=1
MP15 net1 net5 VDD VDD sg13_lv_pmos m=1 w=1.12u l=130.00n ng=1
.ENDS

************************************************************************
* Library Name: sg13cmos5l_stdcell
* Cell Name:    sg13cmos5l_dfrbp_2
* View Name:    schematic
************************************************************************

.SUBCKT sg13cmos5l_dfrbp_2 Q Q_N CLK D RESET_B VDD VSS
*.PININFO CLK:I D:I RESET_B:I Q:O Q_N:O VDD:B VSS:B
MN11 net12 net2 VSS VSS sg13_lv_nmos m=1 w=420.00n l=130.00n ng=1
MN10 net5 clkneg net12 VSS sg13_lv_nmos m=1 w=420.00n l=130.00n ng=1
MN12 net2 net5 net11 VSS sg13_lv_nmos m=1 w=420.00n l=130.00n ng=1
MN13 net11 RESET_B VSS VSS sg13_lv_nmos m=1 w=420.00n l=130.00n ng=1
MN14 Q_N net5 VSS VSS sg13_lv_nmos m=1 w=1.48u l=130.00n ng=2
MN0 Db D net10 VSS sg13_lv_nmos m=1 w=420.00n l=130.00n ng=1
MN1 net10 RESET_B VSS VSS sg13_lv_nmos m=1 w=420.00n l=130.00n ng=1
MN4 Db clkneg net6 VSS sg13_lv_nmos m=1 w=420.00n l=130.00n ng=1
MN5 net6 clkpos net9 VSS sg13_lv_nmos m=1 w=420.00n l=130.00n ng=1
MN6 net9 net4 net8 VSS sg13_lv_nmos m=1 w=420.00n l=130.00n ng=1
MN7 net8 RESET_B VSS VSS sg13_lv_nmos m=1 w=420.00n l=130.00n ng=1
MN8 net4 net6 VSS VSS sg13_lv_nmos m=1 w=740.00n l=130.00n ng=1
MN2 clkneg CLK VSS VSS sg13_lv_nmos m=1 w=740.00n l=130.00n ng=1
MN9 net4 clkpos net5 VSS sg13_lv_nmos m=1 w=740.00n l=130.00n ng=1
MN3 clkpos clkneg VSS VSS sg13_lv_nmos m=1 w=740.00n l=130.00n ng=1
MN16 Q net1 VSS VSS sg13_lv_nmos m=1 w=1.48u l=130.00n ng=2
MN15 net1 net5 VSS VSS sg13_lv_nmos m=1 w=640.00n l=130.00n ng=1
MP11 net5 clkpos net3 VDD sg13_lv_pmos m=1 w=420.00n l=130.00n ng=1
MP12 net2 net5 VDD VDD sg13_lv_pmos m=1 w=420.00n l=130.00n ng=1
MP13 net2 RESET_B VDD VDD sg13_lv_pmos m=1 w=420.00n l=130.00n ng=1
MP14 Q_N net5 VDD VDD sg13_lv_pmos m=1 w=2.24u l=130.00n ng=2
MP4 Db clkpos net6 VDD sg13_lv_pmos m=1 w=420.00n l=130.00n ng=1
MP0 Db RESET_B VDD VDD sg13_lv_pmos m=1 w=420.00n l=130.00n ng=1
MP1 Db D VDD VDD sg13_lv_pmos m=1 w=420.00n l=130.00n ng=1
MP5 net7 net4 VDD VDD sg13_lv_pmos m=1 w=420.00n l=130.00n ng=1
MP6 net6 clkneg net7 VDD sg13_lv_pmos m=1 w=420.00n l=130.00n ng=1
MP7 net6 RESET_B VDD VDD sg13_lv_pmos m=1 w=420.00n l=130.00n ng=1
MP2 clkneg CLK VDD VDD sg13_lv_pmos m=1 w=1.12u l=130.00n ng=1
MP3 clkpos clkneg VDD VDD sg13_lv_pmos m=1 w=1.12u l=130.00n ng=1
MP8 net4 net6 VDD VDD sg13_lv_pmos m=1 w=1.000u l=130.00n ng=1
MP9 net4 clkneg net5 VDD sg13_lv_pmos m=1 w=1.000u l=130.00n ng=1
MP16 Q net1 VDD VDD sg13_lv_pmos m=1 w=2.24u l=130.00n ng=2
MP10 net3 net2 VDD VDD sg13_lv_pmos m=1 w=420.00n l=130.00n ng=1
MP15 net1 net5 VDD VDD sg13_lv_pmos m=1 w=1.000u l=130.00n ng=1
.ENDS

************************************************************************
* Library Name: sg13cmos5l_stdcell
* Cell Name:    sg13cmos5l_dlhq_1
* View Name:    schematic
************************************************************************

.SUBCKT sg13cmos5l_dlhq_1 Q D GATE VDD VSS
*.PININFO D:I GATE:I Q:O VDD:B VSS:B
MP8 Q qint_b VDD VDD sg13_lv_pmos m=1 w=1.12u l=130.00n ng=1
MP6 qint GATE_BB net8 VDD sg13_lv_pmos m=1 w=420.00n l=130.00n ng=1
MP7 qint_b qint VDD VDD sg13_lv_pmos m=1 w=1.12u l=130.00n ng=1
MP2 Db D VDD VDD sg13_lv_pmos m=1 w=840.00n l=130.00n ng=1
MP0 GATE_B GATE VDD VDD sg13_lv_pmos m=1 w=840.00n l=130.00n ng=1
MP1 GATE_BB GATE_B VDD VDD sg13_lv_pmos m=1 w=840.00n l=130.00n ng=1
MP5 net8 qint_b VDD VDD sg13_lv_pmos m=1 w=420.00n l=130.00n ng=1
MP4 net4 GATE_B qint VDD sg13_lv_pmos m=1 w=1.000u l=130.00n ng=1
MP3 net4 Db VDD VDD sg13_lv_pmos m=1 w=1.000u l=130.00n ng=1
MN0 GATE_B GATE VSS VSS sg13_lv_nmos m=1 w=740.00n l=130.00n ng=1
MN1 GATE_BB GATE_B VSS VSS sg13_lv_nmos m=1 w=740.00n l=130.00n ng=1
MN5 qint GATE_B net9 VSS sg13_lv_nmos m=1 w=420.00n l=130.00n ng=1
MN8 Q qint_b VSS VSS sg13_lv_nmos m=1 w=740.00n l=130.00n ng=1
MN4 net7 Db VSS VSS sg13_lv_nmos m=1 w=740.00n l=130.00n ng=1
MN6 net9 qint_b VSS VSS sg13_lv_nmos m=1 w=420.00n l=130.00n ng=1
MN7 qint_b qint VSS VSS sg13_lv_nmos m=1 w=740.00n l=130.00n ng=1
MN3 qint GATE_BB net7 VSS sg13_lv_nmos m=1 w=740.00n l=130.00n ng=1
MN2 Db D VSS VSS sg13_lv_nmos m=1 w=550.00n l=130.00n ng=1
.ENDS

************************************************************************
* Library Name: sg13cmos5l_stdcell
* Cell Name:    sg13cmos5l_dlhr_1
* View Name:    schematic
************************************************************************

.SUBCKT sg13cmos5l_dlhr_1 Q Q_N D GATE RESET_B VDD VSS
*.PININFO D:I GATE:I RESET_B:I Q:O Q_N:O VDD:B VSS:B
MP8 qint_b RESET_B VDD VDD sg13_lv_pmos m=1 w=1.12u l=130.00n ng=1
MP9 Q qint_b VDD VDD sg13_lv_pmos m=1 w=1.12u l=130.00n ng=1
MP6 qint GATE_BB net11 VDD sg13_lv_pmos m=1 w=420.00n l=130.00n ng=1
MP5 net11 qint_b VDD VDD sg13_lv_pmos m=1 w=420.00n l=130.00n ng=1
MP4 qint GATE_B net2 VDD sg13_lv_pmos m=1 w=1.000u l=130.00n ng=1
MP3 net2 Db VDD VDD sg13_lv_pmos m=1 w=1.000u l=130.00n ng=1
MP2 Db D VDD VDD sg13_lv_pmos m=1 w=840.00n l=130.00n ng=1
MP0 GATE_B GATE VDD VDD sg13_lv_pmos m=1 w=840.00n l=130.00n ng=1
MP11 Q_N qintn_b VDD VDD sg13_lv_pmos m=1 w=1.12u l=130.00n ng=1
MP7 qint_b qint VDD VDD sg13_lv_pmos m=1 w=1.12u l=130.00n ng=1
MP1 GATE_BB GATE_B VDD VDD sg13_lv_pmos m=1 w=840.00n l=130.00n ng=1
MP10 qintn_b qint_b VDD VDD sg13_lv_pmos m=1 w=840.00n l=130.00n ng=1
MN7 qint_b qint net9 VSS sg13_lv_nmos m=1 w=740.00n l=130.00n ng=1
MN8 net9 RESET_B VSS VSS sg13_lv_nmos m=1 w=740.00n l=130.00n ng=1
MN5 qint GATE_B net7 VSS sg13_lv_nmos m=1 w=420.00n l=130.00n ng=1
MN6 net7 qint_b VSS VSS sg13_lv_nmos m=1 w=420.00n l=130.00n ng=1
MN9 Q qint_b VSS VSS sg13_lv_nmos m=1 w=740.00n l=130.00n ng=1
MN3 qint GATE_BB net1 VSS sg13_lv_nmos m=1 w=640.00n l=130.00n ng=1
MN4 net1 Db VSS VSS sg13_lv_nmos m=1 w=640.00n l=130.00n ng=1
MN2 Db D VSS VSS sg13_lv_nmos m=1 w=550.00n l=130.00n ng=1
MN0 GATE_B GATE VSS VSS sg13_lv_nmos m=1 w=740.00n l=130.00n ng=1
MN11 Q_N qintn_b VSS VSS sg13_lv_nmos m=1 w=740.00n l=130.00n ng=1
MN1 GATE_BB GATE_B VSS VSS sg13_lv_nmos m=1 w=740.00n l=130.00n ng=1
MN10 qintn_b qint_b VSS VSS sg13_lv_nmos m=1 w=550.00n l=130.00n ng=1
.ENDS

************************************************************************
* Library Name: sg13cmos5l_stdcell
* Cell Name:    sg13cmos5l_dlhrq_1
* View Name:    schematic
************************************************************************

.SUBCKT sg13cmos5l_dlhrq_1 Q D GATE RESET_B VDD VSS
*.PININFO D:I GATE:I RESET_B:I Q:O VDD:B VSS:B
MN8 net116 RESET_B VSS VSS sg13_lv_nmos m=1 w=740.00n l=130.00n ng=1
MN9 Q qint_b VSS VSS sg13_lv_nmos m=1 w=740.00n l=130.00n ng=1
MN1 GATE_BB GATE_B VSS VSS sg13_lv_nmos m=1 w=740.00n l=130.00n ng=1
MN5 qint GATE_B net89 VSS sg13_lv_nmos m=1 w=420.00n l=130.00n ng=1
MN7 qint_b qint net116 VSS sg13_lv_nmos m=1 w=740.00n l=130.00n ng=1
MN2 Db D VSS VSS sg13_lv_nmos m=1 w=550.00n l=130.00n ng=1
MN4 net61 Db VSS VSS sg13_lv_nmos m=1 w=640.00n l=130.00n ng=1
MN3 qint GATE_BB net61 VSS sg13_lv_nmos m=1 w=640.00n l=130.00n ng=1
MN6 net89 qint_b VSS VSS sg13_lv_nmos m=1 w=420.00n l=130.00n ng=1
MN0 GATE_B GATE VSS VSS sg13_lv_nmos m=1 w=740.00n l=130.00n ng=1
MP3 net60 Db VDD VDD sg13_lv_pmos m=1 w=1.000u l=130.00n ng=1
MP8 qint_b RESET_B VDD VDD sg13_lv_pmos m=1 w=1.000u l=130.00n ng=1
MP6 qint GATE_BB net92 VDD sg13_lv_pmos m=1 w=420.00n l=130.00n ng=1
MP9 Q qint_b VDD VDD sg13_lv_pmos m=1 w=1.12u l=130.00n ng=1
MP5 net92 qint_b VDD VDD sg13_lv_pmos m=1 w=420.00n l=130.00n ng=1
MP0 GATE_B GATE VDD VDD sg13_lv_pmos m=1 w=840.00n l=130.00n ng=1
MP2 Db D VDD VDD sg13_lv_pmos m=1 w=840.00n l=130.00n ng=1
MP4 qint GATE_B net60 VDD sg13_lv_pmos m=1 w=1.000u l=130.00n ng=1
MP1 GATE_BB GATE_B VDD VDD sg13_lv_pmos m=1 w=840.00n l=130.00n ng=1
MP7 qint_b qint VDD VDD sg13_lv_pmos m=1 w=1.000u l=130.00n ng=1
.ENDS

************************************************************************
* Library Name: sg13cmos5l_stdcell
* Cell Name:    sg13cmos5l_dllr_1
* View Name:    schematic
************************************************************************

.SUBCKT sg13cmos5l_dllr_1 Q Q_N D GATE_N RESET_B VDD VSS
*.PININFO D:I GATE_N:I RESET_B:I Q:O Q_N:O VDD:B VSS:B
MN2 Db D VSS VSS sg13_lv_nmos m=1 w=550.00n l=130.00n ng=1
MN0 gnb GATE_N VSS VSS sg13_lv_nmos m=1 w=740.00n l=130.00n ng=1
MN1 gnbb gnb VSS VSS sg13_lv_nmos m=1 w=740.00n l=130.00n ng=1
MN6 net89 qint_b VSS VSS sg13_lv_nmos m=1 w=420.00n l=130.00n ng=1
MN7 qint_b qint net116 VSS sg13_lv_nmos m=1 w=740.00n l=130.00n ng=1
MN8 net116 RESET_B VSS VSS sg13_lv_nmos m=1 w=740.00n l=130.00n ng=1
MN5 qint gnbb net89 VSS sg13_lv_nmos m=1 w=420.00n l=130.00n ng=1
MN11 Q_N qintn_b VSS VSS sg13_lv_nmos m=1 w=740.00n l=130.00n ng=1
MN3 qint gnb net61 VSS sg13_lv_nmos m=1 w=640.00n l=130.00n ng=1
MN10 qintn_b qint_b VSS VSS sg13_lv_nmos m=1 w=550.00n l=130.00n ng=1
MN4 net61 Db VSS VSS sg13_lv_nmos m=1 w=640.00n l=130.00n ng=1
MN9 Q qint_b VSS VSS sg13_lv_nmos m=1 w=740.00n l=130.00n ng=1
MP1 gnbb gnb VDD VDD sg13_lv_pmos m=1 w=840.00n l=130.00n ng=1
MP4 qint gnbb net60 VDD sg13_lv_pmos m=1 w=1.000u l=130.00n ng=1
MP10 qintn_b qint_b VDD VDD sg13_lv_pmos m=1 w=840.00n l=130.00n ng=1
MP11 Q_N qintn_b VDD VDD sg13_lv_pmos m=1 w=1.12u l=130.00n ng=1
MP3 net60 Db VDD VDD sg13_lv_pmos m=1 w=1.000u l=130.00n ng=1
MP5 net92 qint_b VDD VDD sg13_lv_pmos m=1 w=420.00n l=130.00n ng=1
MP8 qint_b RESET_B VDD VDD sg13_lv_pmos m=1 w=1.12u l=130.00n ng=1
MP2 Db D VDD VDD sg13_lv_pmos m=1 w=840.00n l=130.00n ng=1
MP0 gnb GATE_N VDD VDD sg13_lv_pmos m=1 w=840.00n l=130.00n ng=1
MP9 Q qint_b VDD VDD sg13_lv_pmos m=1 w=1.12u l=130.00n ng=1
MP6 qint gnb net92 VDD sg13_lv_pmos m=1 w=420.00n l=130.00n ng=1
MP7 qint_b qint VDD VDD sg13_lv_pmos m=1 w=1.12u l=130.00n ng=1
.ENDS

************************************************************************
* Library Name: sg13cmos5l_stdcell
* Cell Name:    sg13cmos5l_dllrq_1
* View Name:    schematic
************************************************************************

.SUBCKT sg13cmos5l_dllrq_1 Q D GATE_N RESET_B VDD VSS
*.PININFO D:I GATE_N:I RESET_B:I Q:O VDD:B VSS:B
MN5 qint gnbb net89 VSS sg13_lv_nmos m=1 w=420.00n l=130.00n ng=1
MN3 qint gnb net61 VSS sg13_lv_nmos m=1 w=640.00n l=130.00n ng=1
MN8 net116 RESET_B VSS VSS sg13_lv_nmos m=1 w=740.00n l=130.00n ng=1
MN9 Q qint_b VSS VSS sg13_lv_nmos m=1 w=740.00n l=130.00n ng=1
MN4 net61 Db VSS VSS sg13_lv_nmos m=1 w=640.00n l=130.00n ng=1
MN6 net89 qint_b VSS VSS sg13_lv_nmos m=1 w=420.00n l=130.00n ng=1
MN7 qint_b qint net116 VSS sg13_lv_nmos m=1 w=740.00n l=130.00n ng=1
MN2 Db D VSS VSS sg13_lv_nmos m=1 w=550.00n l=130.00n ng=1
MN0 gnb GATE_N VSS VSS sg13_lv_nmos m=1 w=740.00n l=130.00n ng=1
MN1 gnbb gnb VSS VSS sg13_lv_nmos m=1 w=740.00n l=130.00n ng=1
MP3 net59 Db VDD VDD sg13_lv_pmos m=1 w=1.000u l=130.00n ng=1
MP8 qint_b RESET_B VDD VDD sg13_lv_pmos m=1 w=1.000u l=130.00n ng=1
MP0 gnb GATE_N VDD VDD sg13_lv_pmos m=1 w=840.00n l=130.00n ng=1
MP5 net92 qint_b VDD VDD sg13_lv_pmos m=1 w=420.00n l=130.00n ng=1
MP7 qint_b qint VDD VDD sg13_lv_pmos m=1 w=1.000u l=130.00n ng=1
MP9 Q qint_b VDD VDD sg13_lv_pmos m=1 w=1.12u l=130.00n ng=1
MP4 qint gnbb net59 VDD sg13_lv_pmos m=1 w=1.000u l=130.00n ng=1
MP2 Db D VDD VDD sg13_lv_pmos m=1 w=840.00n l=130.00n ng=1
MP1 gnbb gnb VDD VDD sg13_lv_pmos m=1 w=840.00n l=130.00n ng=1
MP6 qint gnb net92 VDD sg13_lv_pmos m=1 w=420.00n l=130.00n ng=1
.ENDS

************************************************************************
* Library Name: sg13cmos5l_stdcell
* Cell Name:    sg13cmos5l_dlygate4sd1_1
* View Name:    schematic
************************************************************************

.SUBCKT sg13cmos5l_dlygate4sd1_1 X A VDD VSS
*.PININFO A:I X:O VDD:B VSS:B
MP3 X net3 VDD VDD sg13_lv_pmos m=1 w=1.12u l=130.00n ng=1
MP2 net3 net2 VDD VDD sg13_lv_pmos m=1 w=1.000u l=130.00n ng=1
MP1 net2 net1 VDD VDD sg13_lv_pmos m=1 w=1.000u l=130.00n ng=1
MP0 net1 A VDD VDD sg13_lv_pmos m=1 w=420.00n l=130.00n ng=1
MN3 X net3 VSS VSS sg13_lv_nmos m=1 w=740.00n l=130.00n ng=1
MN2 net3 net2 VSS VSS sg13_lv_nmos m=1 w=420.00n l=130.00n ng=1
MN1 net2 net1 VSS VSS sg13_lv_nmos m=1 w=420.00n l=130.00n ng=1
MN0 net1 A VSS VSS sg13_lv_nmos m=1 w=420.00n l=130.00n ng=1
.ENDS

************************************************************************
* Library Name: sg13cmos5l_stdcell
* Cell Name:    sg13cmos5l_dlygate4sd2_1
* View Name:    schematic
************************************************************************

.SUBCKT sg13cmos5l_dlygate4sd2_1 X A VDD VSS
*.PININFO A:I X:O VDD:B VSS:B
MP3 X net3 VDD VDD sg13_lv_pmos m=1 w=1.12u l=130.00n ng=1
MP2 net3 net2 VDD VDD sg13_lv_pmos m=1 w=1.000u l=250.00n ng=1
MP1 net2 net1 VDD VDD sg13_lv_pmos m=1 w=1.000u l=250.00n ng=1
MP0 net1 A VDD VDD sg13_lv_pmos m=1 w=420.00n l=130.00n ng=1
MN3 X net3 VSS VSS sg13_lv_nmos m=1 w=740.00n l=130.00n ng=1
MN2 net3 net2 VSS VSS sg13_lv_nmos m=1 w=420.00n l=180.00n ng=1
MN1 net2 net1 VSS VSS sg13_lv_nmos m=1 w=420.00n l=180.00n ng=1
MN0 net1 A VSS VSS sg13_lv_nmos m=1 w=420.00n l=130.00n ng=1
.ENDS

************************************************************************
* Library Name: sg13cmos5l_stdcell
* Cell Name:    sg13cmos5l_dlygate4sd3_1
* View Name:    schematic
************************************************************************

.SUBCKT sg13cmos5l_dlygate4sd3_1 X A VDD VSS
*.PININFO A:I X:O VDD:B VSS:B
MP3 X net3 VDD VDD sg13_lv_pmos m=1 w=1.12u l=130.00n ng=1
MP2 net3 net2 VDD VDD sg13_lv_pmos m=1 w=1.000u l=500.0n ng=1
MP1 net2 net1 VDD VDD sg13_lv_pmos m=1 w=1.000u l=500.0n ng=1
MP0 net1 A VDD VDD sg13_lv_pmos m=1 w=420.00n l=130.00n ng=1
MN3 X net3 VSS VSS sg13_lv_nmos m=1 w=740.00n l=130.00n ng=1
MN2 net3 net2 VSS VSS sg13_lv_nmos m=1 w=420.00n l=500.0n ng=1
MN1 net2 net1 VSS VSS sg13_lv_nmos m=1 w=420.00n l=500.0n ng=1
MN0 net1 A VSS VSS sg13_lv_nmos m=1 w=420.00n l=130.00n ng=1
.ENDS

************************************************************************
* Library Name: sg13cmos5l_stdcell
* Cell Name:    sg13cmos5l_ebufn_2
* View Name:    schematic
************************************************************************

.SUBCKT sg13cmos5l_ebufn_2 Z A TE_B VDD VSS
*.PININFO A:I TE_B:I Z:O VDD:B VSS:B
MN3 net4 net3 VSS VSS sg13_lv_nmos m=1 w=1.48u l=130.00n ng=2
MN2 Z net1 net4 VSS sg13_lv_nmos m=1 w=1.48u l=130.00n ng=2
MN1 net3 TE_B VSS VSS sg13_lv_nmos m=1 w=640.00n l=130.00n ng=1
MN0 net1 A VSS VSS sg13_lv_nmos m=1 w=640.00n l=130.00n ng=1
MP2 net2 TE_B VDD VDD sg13_lv_pmos m=1 w=2.24u l=130.00n ng=2
MP3 Z net1 net2 VDD sg13_lv_pmos m=1 w=2.24u l=130.00n ng=2
MP1 net3 TE_B VDD VDD sg13_lv_pmos m=1 w=1.000u l=130.00n ng=1
MP0 net1 A VDD VDD sg13_lv_pmos m=1 w=1.000u l=130.00n ng=1
.ENDS

************************************************************************
* Library Name: sg13cmos5l_stdcell
* Cell Name:    sg13cmos5l_ebufn_4
* View Name:    schematic
************************************************************************

.SUBCKT sg13cmos5l_ebufn_4 Z A TE_B VDD VSS
*.PININFO A:I TE_B:I Z:O VDD:B VSS:B
MN0 net23 A VSS VSS sg13_lv_nmos m=1 w=740.00n l=130.00n ng=1
MN1 net21 TE_B VSS VSS sg13_lv_nmos m=1 w=740.00n l=130.00n ng=1
MN2 Z net23 net22 VSS sg13_lv_nmos m=1 w=2.96u l=130.00n ng=4
MN3 net22 net21 VSS VSS sg13_lv_nmos m=1 w=2.96u l=130.00n ng=4
MP0 net23 A VDD VDD sg13_lv_pmos m=1 w=1.12u l=130.00n ng=1
MP1 net21 TE_B VDD VDD sg13_lv_pmos m=1 w=1.12u l=130.00n ng=1
MP3 Z net23 net24 VDD sg13_lv_pmos m=1 w=4.48u l=130.00n ng=4
MP2 net24 TE_B VDD VDD sg13_lv_pmos m=1 w=4.48u l=130.00n ng=4
.ENDS

************************************************************************
* Library Name: sg13cmos5l_stdcell
* Cell Name:    sg13cmos5l_ebufn_8
* View Name:    schematic
************************************************************************

.SUBCKT sg13cmos5l_ebufn_8 Z A TE_B VDD VSS
*.PININFO A:I TE_B:I Z:O VDD:B VSS:B
MN3 net23 net22 VSS VSS sg13_lv_nmos m=1 w=5.92u l=130.00n ng=8
MN2 Z net21 net23 VSS sg13_lv_nmos m=1 w=5.92u l=130.00n ng=8
MN1 net22 TE_B VSS VSS sg13_lv_nmos m=1 w=740.00n l=130.00n ng=1
MN0 net21 A VSS VSS sg13_lv_nmos m=1 w=1.48u l=130.00n ng=2
MP2 net24 TE_B VDD VDD sg13_lv_pmos m=1 w=8.96u l=130.00n ng=8
MP3 Z net21 net24 VDD sg13_lv_pmos m=1 w=8.96u l=130.00n ng=8
MP1 net22 TE_B VDD VDD sg13_lv_pmos m=1 w=1.12u l=130.00n ng=1
MP0 net21 A VDD VDD sg13_lv_pmos m=1 w=2.24u l=130.00n ng=2
.ENDS

************************************************************************
* Library Name: sg13cmos5l_stdcell
* Cell Name:    sg13cmos5l_einvn_2
* View Name:    schematic
************************************************************************

.SUBCKT sg13cmos5l_einvn_2 Z A TE_B VDD VSS
*.PININFO A:I TE_B:I Z:O VDD:B VSS:B
MN0 TE TE_B VSS VSS sg13_lv_nmos m=1 w=420.00n l=130.00n ng=1
MN2 net1 TE VSS VSS sg13_lv_nmos m=1 w=1.48u l=130.00n ng=2
MN1 Z A net1 VSS sg13_lv_nmos m=1 w=1.48u l=130.00n ng=2
MP0 TE TE_B VDD VDD sg13_lv_pmos m=1 w=640.00n l=130.00n ng=1
MP1 net2 TE_B VDD VDD sg13_lv_pmos m=1 w=2.24u l=130.00n ng=2
MP2 Z A net2 VDD sg13_lv_pmos m=1 w=2.24u l=130.00n ng=2
.ENDS

************************************************************************
* Library Name: sg13cmos5l_stdcell
* Cell Name:    sg13cmos5l_einvn_4
* View Name:    schematic
************************************************************************

.SUBCKT sg13cmos5l_einvn_4 Z A TE_B VDD VSS
*.PININFO A:I TE_B:I Z:O VDD:B VSS:B
MN2 net16 TE VSS VSS sg13_lv_nmos m=1 w=2.96u l=130.00n ng=4
MN0 TE TE_B VSS VSS sg13_lv_nmos m=1 w=740.00n l=130.00n ng=1
MN1 Z A net16 VSS sg13_lv_nmos m=1 w=2.96u l=130.00n ng=4
MP0 TE TE_B VDD VDD sg13_lv_pmos m=1 w=1.12u l=130.00n ng=1
MP1 net17 TE_B VDD VDD sg13_lv_pmos m=1 w=4.48u l=130.00n ng=4
MP2 Z A net17 VDD sg13_lv_pmos m=1 w=4.48u l=130.00n ng=4
.ENDS

************************************************************************
* Library Name: sg13cmos5l_stdcell
* Cell Name:    sg13cmos5l_einvn_8
* View Name:    schematic
************************************************************************

.SUBCKT sg13cmos5l_einvn_8 Z A TE_B VDD VSS
*.PININFO A:I TE_B:I Z:O VDD:B VSS:B
MN1 Z A net29 VSS sg13_lv_nmos m=1 w=5.92u l=130.00n ng=8
MN0 TE TE_B VSS VSS sg13_lv_nmos m=1 w=740.00n l=130.00n ng=1
MN2 net29 TE VSS VSS sg13_lv_nmos m=1 w=5.92u l=130.00n ng=8
MP1 net28 TE_B VDD VDD sg13_lv_pmos m=1 w=8.96u l=130.00n ng=8
MP2 Z A net28 VDD sg13_lv_pmos m=1 w=8.96u l=130.00n ng=8
MP0 TE TE_B VDD VDD sg13_lv_pmos m=1 w=1.12u l=130.00n ng=1
.ENDS

************************************************************************
* Library Name: sg13cmos5l_stdcell
* Cell Name:    sg13cmos5l_inv_1
* View Name:    schematic
************************************************************************

.SUBCKT sg13cmos5l_inv_1 Y A VDD VSS
*.PININFO A:I Y:O VDD:B VSS:B
MN0 Y A VSS VSS sg13_lv_nmos m=1 w=740.00n l=130.00n ng=1
MP0 Y A VDD VDD sg13_lv_pmos m=1 w=1.12u l=130.00n ng=1
.ENDS

************************************************************************
* Library Name: sg13cmos5l_stdcell
* Cell Name:    sg13cmos5l_inv_16
* View Name:    schematic
************************************************************************

.SUBCKT sg13cmos5l_inv_16 Y A VDD VSS
*.PININFO A:I Y:O VDD:B VSS:B
MN0 Y A VSS VSS sg13_lv_nmos m=1 w=11.84u l=130.00n ng=16
MP0 Y A VDD VDD sg13_lv_pmos m=1 w=17.92u l=130.00n ng=16
.ENDS

************************************************************************
* Library Name: sg13cmos5l_stdcell
* Cell Name:    sg13cmos5l_inv_2
* View Name:    schematic
************************************************************************

.SUBCKT sg13cmos5l_inv_2 Y A VDD VSS
*.PININFO A:I Y:O VDD:B VSS:B
MN0 Y A VSS VSS sg13_lv_nmos m=1 w=1.48u l=130.00n ng=2
MP0 Y A VDD VDD sg13_lv_pmos m=1 w=2.24u l=130.00n ng=2
.ENDS

************************************************************************
* Library Name: sg13cmos5l_stdcell
* Cell Name:    sg13cmos5l_inv_4
* View Name:    schematic
************************************************************************

.SUBCKT sg13cmos5l_inv_4 Y A VDD VSS
*.PININFO A:I Y:O VDD:B VSS:B
MP0 Y A VDD VDD sg13_lv_pmos m=1 w=4.48u l=130.00n ng=4
MN0 Y A VSS VSS sg13_lv_nmos m=1 w=2.96u l=130.00n ng=4
.ENDS

************************************************************************
* Library Name: sg13cmos5l_stdcell
* Cell Name:    sg13cmos5l_inv_8
* View Name:    schematic
************************************************************************

.SUBCKT sg13cmos5l_inv_8 Y A VDD VSS
*.PININFO A:I Y:O VDD:B VSS:B
MN0 Y A VSS VSS sg13_lv_nmos m=1 w=5.92u l=130.00n ng=8
MP0 Y A VDD VDD sg13_lv_pmos m=1 w=8.96u l=130.00n ng=8
.ENDS

************************************************************************
* Library Name: sg13cmos5l_stdcell
* Cell Name:    sg13cmos5l_lgcp_1
* View Name:    schematic
************************************************************************

.SUBCKT sg13cmos5l_lgcp_1 GCLK CLK GATE VDD VSS
*.PININFO CLK:I GATE:I GCLK:O VDD:B VSS:B
MP1 CLKBB CLKB VDD VDD sg13_lv_pmos m=1 w=840.00n l=130.00n ng=1
MP3 net1 CLKBB net4 VDD sg13_lv_pmos m=1 w=1.000u l=130.00n ng=1
MP4 int_GATE net1 VDD VDD sg13_lv_pmos m=1 w=1.12u l=130.00n ng=1
MP2 net4 GATE VDD VDD sg13_lv_pmos m=1 w=1.000u l=130.00n ng=1
MP8 net3 int_GATE VDD VDD sg13_lv_pmos m=1 w=840.00n l=130.00n ng=1
MP9 GCLK net3 VDD VDD sg13_lv_pmos m=1 w=1.12u l=130.00n ng=1
MP6 net1 CLKB net6 VDD sg13_lv_pmos m=1 w=420.00n l=130.00n ng=1
MP0 CLKB CLK VDD VDD sg13_lv_pmos m=1 w=840.00n l=130.00n ng=1
MP7 net3 CLK VDD VDD sg13_lv_pmos m=1 w=840.00n l=130.00n ng=1
MP5 net6 int_GATE VDD VDD sg13_lv_pmos m=1 w=420.00n l=130.00n ng=1
MN9 GCLK net3 VSS VSS sg13_lv_nmos m=1 w=740.00n l=130.00n ng=1
MN7 net3 int_GATE net5 VSS sg13_lv_nmos m=1 w=640.00n l=130.00n ng=1
MN4 int_GATE net1 VSS VSS sg13_lv_nmos m=1 w=740.00n l=130.00n ng=1
MN1 CLKBB CLKB VSS VSS sg13_lv_nmos m=1 w=740.00n l=130.00n ng=1
MN6 net7 int_GATE VSS VSS sg13_lv_nmos m=1 w=420.00n l=130.00n ng=1
MN3 net2 GATE VSS VSS sg13_lv_nmos m=1 w=640.00n l=130.00n ng=1
MN5 net1 CLKBB net7 VSS sg13_lv_nmos m=1 w=420.00n l=130.00n ng=1
MN0 CLKB CLK VSS VSS sg13_lv_nmos m=1 w=740.00n l=130.00n ng=1
MN8 net5 CLK VSS VSS sg13_lv_nmos m=1 w=640.00n l=130.00n ng=1
MN2 net1 CLKB net2 VSS sg13_lv_nmos m=1 w=640.00n l=130.00n ng=1
.ENDS

************************************************************************
* Library Name: sg13cmos5l_stdcell
* Cell Name:    sg13cmos5l_mux2_1
* View Name:    schematic
************************************************************************

.SUBCKT sg13cmos5l_mux2_1 X A0 A1 S VDD VSS
*.PININFO A0:I A1:I S:I X:O VDD:B VSS:B
MP1 net4 S VDD VDD sg13_lv_pmos m=1 w=1.000u l=130.00n ng=1
MP5 X net6 VDD VDD sg13_lv_pmos m=1 w=1.12u l=130.00n ng=1
MP4 net6 A1 net5 VDD sg13_lv_pmos m=1 w=1.000u l=130.00n ng=1
MP0 Sb S VDD VDD sg13_lv_pmos m=1 w=840.00n l=130.00n ng=1
MP3 net5 Sb VDD VDD sg13_lv_pmos m=1 w=1.000u l=130.00n ng=1
MP2 net6 A0 net4 VDD sg13_lv_pmos m=1 w=1.000u l=130.00n ng=1
MN4 net3 S VSS VSS sg13_lv_nmos m=1 w=740.00n l=130.00n ng=1
MN2 net1 Sb VSS VSS sg13_lv_nmos m=1 w=740.00n l=130.00n ng=1
MN5 X net6 VSS VSS sg13_lv_nmos m=1 w=740.00n l=130.00n ng=1
MN0 Sb S VSS VSS sg13_lv_nmos m=1 w=550.00n l=130.00n ng=1
MN3 net6 A1 net3 VSS sg13_lv_nmos m=1 w=740.00n l=130.00n ng=1
MN1 net6 A0 net1 VSS sg13_lv_nmos m=1 w=740.00n l=130.00n ng=1
.ENDS

************************************************************************
* Library Name: sg13cmos5l_stdcell
* Cell Name:    sg13cmos5l_mux2_2
* View Name:    schematic
************************************************************************

.SUBCKT sg13cmos5l_mux2_2 X A0 A1 S VDD VSS
*.PININFO A0:I A1:I S:I X:O VDD:B VSS:B
MP1 net4 S VDD VDD sg13_lv_pmos m=1 w=1.000u l=130.00n ng=1
MP5 X net6 VDD VDD sg13_lv_pmos m=1 w=2.24u l=130.00n ng=2
MP4 net6 A1 net5 VDD sg13_lv_pmos m=1 w=1.000u l=130.00n ng=1
MP0 Sb S VDD VDD sg13_lv_pmos m=1 w=840.00n l=130.00n ng=1
MP3 net5 Sb VDD VDD sg13_lv_pmos m=1 w=1.000u l=130.00n ng=1
MP2 net6 A0 net4 VDD sg13_lv_pmos m=1 w=1.000u l=130.00n ng=1
MN4 net3 S VSS VSS sg13_lv_nmos m=1 w=740.00n l=130.00n ng=1
MN2 net1 Sb VSS VSS sg13_lv_nmos m=1 w=740.00n l=130.00n ng=1
MN5 X net6 VSS VSS sg13_lv_nmos m=1 w=1.48u l=130.00n ng=2
MN0 Sb S VSS VSS sg13_lv_nmos m=1 w=550.00n l=130.00n ng=1
MN3 net6 A1 net3 VSS sg13_lv_nmos m=1 w=740.00n l=130.00n ng=1
MN1 net6 A0 net1 VSS sg13_lv_nmos m=1 w=740.00n l=130.00n ng=1
.ENDS

************************************************************************
* Library Name: sg13cmos5l_stdcell
* Cell Name:    sg13cmos5l_mux4_1
* View Name:    schematic
************************************************************************

.SUBCKT sg13cmos5l_mux4_1 X A0 A1 A2 A3 S0 S1 VDD VSS
*.PININFO A0:I A1:I A2:I A3:I S0:I S1:I X:O VDD:B VSS:B
MN12 X Xb VSS VSS sg13_lv_nmos m=1 w=740.00n l=130.00n ng=1
MN2 low S0b net7 VSS sg13_lv_nmos m=1 w=640.00n l=130.00n ng=1
MN3 net7 A0 VSS VSS sg13_lv_nmos m=1 w=640.00n l=130.00n ng=1
MN6 low S1b Xb VSS sg13_lv_nmos m=1 w=640.00n l=130.00n ng=1
MN11 high S1 Xb VSS sg13_lv_nmos m=1 w=640.00n l=130.00n ng=1
MN10 net4 A3 VSS VSS sg13_lv_nmos m=1 w=640.00n l=130.00n ng=1
MN9 high S0 net4 VSS sg13_lv_nmos m=1 w=640.00n l=130.00n ng=1
MN8 net6 A2 VSS VSS sg13_lv_nmos m=1 w=640.00n l=130.00n ng=1
MN7 high S0b net6 VSS sg13_lv_nmos m=1 w=640.00n l=130.00n ng=1
MN5 net2 A1 VSS VSS sg13_lv_nmos m=1 w=640.00n l=130.00n ng=1
MN4 low S0 net2 VSS sg13_lv_nmos m=1 w=640.00n l=130.00n ng=1
MN1 S1b S1 VSS VSS sg13_lv_nmos m=1 w=640.00n l=130.00n ng=1
MN0 S0b S0 VSS VSS sg13_lv_nmos m=1 w=640.00n l=130.00n ng=1
MP6 low S1 Xb VDD sg13_lv_pmos m=1 w=1.000u l=130.00n ng=1
MP11 high S1b Xb VDD sg13_lv_pmos m=1 w=1.000u l=130.00n ng=1
MP12 X Xb VDD VDD sg13_lv_pmos m=1 w=1.12u l=130.00n ng=1
MP10 high S0b net3 VDD sg13_lv_pmos m=1 w=1.000u l=130.00n ng=1
MP9 net3 A3 VDD VDD sg13_lv_pmos m=1 w=1.000u l=130.00n ng=1
MP8 high S0 net5 VDD sg13_lv_pmos m=1 w=1.000u l=130.00n ng=1
MP7 net5 A2 VDD VDD sg13_lv_pmos m=1 w=1.000u l=130.00n ng=1
MP2 net8 A0 VDD VDD sg13_lv_pmos m=1 w=1.000u l=130.00n ng=1
MP3 low S0 net8 VDD sg13_lv_pmos m=1 w=1.000u l=130.00n ng=1
MP1 S1b S1 VDD VDD sg13_lv_pmos m=1 w=1.000u l=130.00n ng=1
MP0 S0b S0 VDD VDD sg13_lv_pmos m=1 w=1.000u l=130.00n ng=1
MP5 low S0b net1 VDD sg13_lv_pmos m=1 w=1.000u l=130.00n ng=1
MP4 net1 A1 VDD VDD sg13_lv_pmos m=1 w=1.000u l=130.00n ng=1
.ENDS

************************************************************************
* Library Name: sg13cmos5l_stdcell
* Cell Name:    sg13cmos5l_nand2_1
* View Name:    schematic
************************************************************************

.SUBCKT sg13cmos5l_nand2_1 Y A B VDD VSS
*.PININFO A:I B:I Y:O VDD:B VSS:B
MP1 Y B VDD VDD sg13_lv_pmos m=1 w=1.12u l=130.00n ng=1
MP0 Y A VDD VDD sg13_lv_pmos m=1 w=1.12u l=130.00n ng=1
MN1 net1 B VSS VSS sg13_lv_nmos m=1 w=740.00n l=130.00n ng=1
MN0 Y A net1 VSS sg13_lv_nmos m=1 w=740.00n l=130.00n ng=1
.ENDS

************************************************************************
* Library Name: sg13cmos5l_stdcell
* Cell Name:    sg13cmos5l_nand2_2
* View Name:    schematic
************************************************************************

.SUBCKT sg13cmos5l_nand2_2 Y A B VDD VSS
*.PININFO A:I B:I Y:O VDD:B VSS:B
MP1 Y B VDD VDD sg13_lv_pmos m=1 w=2.24u l=130.00n ng=2
MP0 Y A VDD VDD sg13_lv_pmos m=1 w=2.24u l=130.00n ng=2
MN1 net1 B VSS VSS sg13_lv_nmos m=1 w=1.44u l=130.00n ng=2
MN0 Y A net1 VSS sg13_lv_nmos m=1 w=1.44u l=130.00n ng=2
.ENDS

************************************************************************
* Library Name: sg13cmos5l_stdcell
* Cell Name:    sg13cmos5l_nand2b_1
* View Name:    schematic
************************************************************************

.SUBCKT sg13cmos5l_nand2b_1 Y A_N B VDD VSS
*.PININFO A_N:I B:I Y:O VDD:B VSS:B
MP2 Y net2 VDD VDD sg13_lv_pmos m=1 w=1.12u l=130.00n ng=1
MP1 net2 A_N VDD VDD sg13_lv_pmos m=1 w=840.00n l=130.00n ng=1
MP0 Y B VDD VDD sg13_lv_pmos m=1 w=1.12u l=130.00n ng=1
MN1 Y net2 net1 VSS sg13_lv_nmos m=1 w=740.00n l=130.00n ng=1
MN0 net2 A_N VSS VSS sg13_lv_nmos m=1 w=550.00n l=130.00n ng=1
MN2 net1 B VSS VSS sg13_lv_nmos m=1 w=740.00n l=130.00n ng=1
.ENDS

************************************************************************
* Library Name: sg13cmos5l_stdcell
* Cell Name:    sg13cmos5l_nand2b_2
* View Name:    schematic
************************************************************************

.SUBCKT sg13cmos5l_nand2b_2 Y A_N B VDD VSS
*.PININFO A_N:I B:I Y:O VDD:B VSS:B
MP2 Y A VDD VDD sg13_lv_pmos m=1 w=2.24u l=130.00n ng=2
MP0 A A_N VDD VDD sg13_lv_pmos m=1 w=840.00n l=130.00n ng=1
MP1 Y B VDD VDD sg13_lv_pmos m=1 w=2.24u l=130.00n ng=2
MN1 Y B net1 VSS sg13_lv_nmos m=1 w=1.44u l=130.00n ng=2
MN0 A A_N VSS VSS sg13_lv_nmos m=1 w=550.00n l=130.00n ng=1
MN2 net1 A VSS VSS sg13_lv_nmos m=1 w=1.44u l=130.00n ng=2
.ENDS

************************************************************************
* Library Name: sg13cmos5l_stdcell
* Cell Name:    sg13cmos5l_nand3_1
* View Name:    schematic
************************************************************************

.SUBCKT sg13cmos5l_nand3_1 Y A B C VDD VSS
*.PININFO A:I B:I C:I Y:O VDD:B VSS:B
MP0 Y A VDD VDD sg13_lv_pmos m=1 w=1.12u l=130.00n ng=1
MP1 Y B VDD VDD sg13_lv_pmos m=1 w=1.12u l=130.00n ng=1
MP2 Y C VDD VDD sg13_lv_pmos m=1 w=1.12u l=130.00n ng=1
MN1 net2 B net3 VSS sg13_lv_nmos m=1 w=740.00n l=130.00n ng=1
MN2 net3 C VSS VSS sg13_lv_nmos m=1 w=740.00n l=130.00n ng=1
MN0 Y A net2 VSS sg13_lv_nmos m=1 w=740.00n l=130.00n ng=1
.ENDS

************************************************************************
* Library Name: sg13cmos5l_stdcell
* Cell Name:    sg13cmos5l_nand3b_1
* View Name:    schematic
************************************************************************

.SUBCKT sg13cmos5l_nand3b_1 Y A_N B C VDD VSS
*.PININFO A_N:I B:I C:I Y:O VDD:B VSS:B
MP0 net1 A_N VDD VDD sg13_lv_pmos m=1 w=840.00n l=130.00n ng=1
MP1 Y net1 VDD VDD sg13_lv_pmos m=1 w=1.12u l=130.00n ng=1
MP2 Y B VDD VDD sg13_lv_pmos m=1 w=1.12u l=130.00n ng=1
MP3 Y C VDD VDD sg13_lv_pmos m=1 w=1.12u l=130.00n ng=1
MN2 net2 B net3 VSS sg13_lv_nmos m=1 w=740.00n l=130.00n ng=1
MN3 net3 C VSS VSS sg13_lv_nmos m=1 w=740.00n l=130.00n ng=1
MN0 net1 A_N VSS VSS sg13_lv_nmos m=1 w=550.00n l=130.00n ng=1
MN1 Y net1 net2 VSS sg13_lv_nmos m=1 w=740.00n l=130.00n ng=1
.ENDS

************************************************************************
* Library Name: sg13cmos5l_stdcell
* Cell Name:    sg13cmos5l_nand4_1
* View Name:    schematic
************************************************************************

.SUBCKT sg13cmos5l_nand4_1 Y A B C D VDD VSS
*.PININFO A:I B:I C:I D:I Y:O VDD:B VSS:B
MP3 Y D VDD VDD sg13_lv_pmos m=1 w=1.12u l=130.00n ng=1
MP0 Y A VDD VDD sg13_lv_pmos m=1 w=1.12u l=130.00n ng=1
MP1 Y B VDD VDD sg13_lv_pmos m=1 w=1.12u l=130.00n ng=1
MP2 Y C VDD VDD sg13_lv_pmos m=1 w=1.12u l=130.00n ng=1
MN1 net2 B net3 VSS sg13_lv_nmos m=1 w=740.00n l=130.00n ng=1
MN2 net3 C net5 VSS sg13_lv_nmos m=1 w=740.00n l=130.00n ng=1
MN0 Y A net2 VSS sg13_lv_nmos m=1 w=740.00n l=130.00n ng=1
MN3 net5 D VSS VSS sg13_lv_nmos m=1 w=740.00n l=130.00n ng=1
.ENDS

************************************************************************
* Library Name: sg13cmos5l_stdcell
* Cell Name:    sg13cmos5l_nor2_1
* View Name:    schematic
************************************************************************

.SUBCKT sg13cmos5l_nor2_1 Y A B VDD VSS
*.PININFO A:I B:I Y:O VDD:B VSS:B
MN0 Y A VSS VSS sg13_lv_nmos m=1 w=740.00n l=130.00n ng=1
MN1 Y B VSS VSS sg13_lv_nmos m=1 w=740.00n l=130.00n ng=1
MP0 net1 A VDD VDD sg13_lv_pmos m=1 w=1.12u l=130.00n ng=1
MP1 Y B net1 VDD sg13_lv_pmos m=1 w=1.12u l=130.00n ng=1
.ENDS

************************************************************************
* Library Name: sg13cmos5l_stdcell
* Cell Name:    sg13cmos5l_nor2_2
* View Name:    schematic
************************************************************************

.SUBCKT sg13cmos5l_nor2_2 Y A B VDD VSS
*.PININFO A:I B:I Y:O VDD:B VSS:B
MN0 Y A VSS VSS sg13_lv_nmos m=1 w=1.48u l=130.00n ng=2
MN1 Y B VSS VSS sg13_lv_nmos m=1 w=1.48u l=130.00n ng=2
MP0 net1 A VDD VDD sg13_lv_pmos m=1 w=2.24u l=130.00n ng=2
MP1 Y B net1 VDD sg13_lv_pmos m=1 w=2.24u l=130.00n ng=2
.ENDS

************************************************************************
* Library Name: sg13cmos5l_stdcell
* Cell Name:    sg13cmos5l_nor2b_1
* View Name:    schematic
************************************************************************

.SUBCKT sg13cmos5l_nor2b_1 Y A B_N VDD VSS
*.PININFO A:I B_N:I Y:O VDD:B VSS:B
MN0 B B_N VSS VSS sg13_lv_nmos m=1 w=550.00n l=130.00n ng=1
MN1 Y A VSS VSS sg13_lv_nmos m=1 w=740.00n l=130.00n ng=1
MN2 Y B VSS VSS sg13_lv_nmos m=1 w=740.00n l=130.00n ng=1
MP0 B B_N VDD VDD sg13_lv_pmos m=1 w=840.00n l=130.00n ng=1
MP1 net1 B VDD VDD sg13_lv_pmos m=1 w=1.12u l=130.00n ng=1
MP2 Y A net1 VDD sg13_lv_pmos m=1 w=1.12u l=130.00n ng=1
.ENDS

************************************************************************
* Library Name: sg13cmos5l_stdcell
* Cell Name:    sg13cmos5l_nor2b_2
* View Name:    schematic
************************************************************************

.SUBCKT sg13cmos5l_nor2b_2 Y A B_N VDD VSS
*.PININFO A:I B_N:I Y:O VDD:B VSS:B
MN0 B B_N VSS VSS sg13_lv_nmos m=1 w=640.00n l=130.00n ng=1
MN1 Y A VSS VSS sg13_lv_nmos m=1 w=1.44u l=130.00n ng=2
MN2 Y B VSS VSS sg13_lv_nmos m=1 w=1.44u l=130.00n ng=2
MP0 B B_N VDD VDD sg13_lv_pmos m=1 w=1.000u l=130.00n ng=1
MP1 net1 B VDD VDD sg13_lv_pmos m=1 w=2.24u l=130.00n ng=2
MP2 Y A net1 VDD sg13_lv_pmos m=1 w=2.24u l=130.00n ng=2
.ENDS

************************************************************************
* Library Name: sg13cmos5l_stdcell
* Cell Name:    sg13cmos5l_nor3_1
* View Name:    schematic
************************************************************************

.SUBCKT sg13cmos5l_nor3_1 Y A B C VDD VSS
*.PININFO A:I B:I C:I Y:O VDD:B VSS:B
MP2 Y C net2 VDD sg13_lv_pmos m=1 w=1.12u l=130.00n ng=1
MP1 net2 B net3 VDD sg13_lv_pmos m=1 w=1.12u l=130.00n ng=1
MP0 net3 A VDD VDD sg13_lv_pmos m=1 w=1.12u l=130.00n ng=1
MN0 Y A VSS VSS sg13_lv_nmos m=1 w=770.00n l=130.00n ng=1
MN1 Y B VSS VSS sg13_lv_nmos m=1 w=770.00n l=130.00n ng=1
MN2 Y C VSS VSS sg13_lv_nmos m=1 w=770.00n l=130.00n ng=1
.ENDS

************************************************************************
* Library Name: sg13cmos5l_stdcell
* Cell Name:    sg13cmos5l_nor3_2
* View Name:    schematic
************************************************************************

.SUBCKT sg13cmos5l_nor3_2 Y A B C VDD VSS
*.PININFO A:I B:I C:I Y:O VDD:B VSS:B
MP2 Y C net2 VDD sg13_lv_pmos m=1 w=2.24u l=130.00n ng=2
MP1 net2 B net3 VDD sg13_lv_pmos m=1 w=2.24u l=130.00n ng=2
MP0 net3 A VDD VDD sg13_lv_pmos m=1 w=2.24u l=130.00n ng=2
MN0 Y A VSS VSS sg13_lv_nmos m=1 w=1.48u l=130.00n ng=2
MN1 Y B VSS VSS sg13_lv_nmos m=1 w=1.48u l=130.00n ng=2
MN2 Y C VSS VSS sg13_lv_nmos m=1 w=1.48u l=130.00n ng=2
.ENDS

************************************************************************
* Library Name: sg13cmos5l_stdcell
* Cell Name:    sg13cmos5l_nor4_1
* View Name:    schematic
************************************************************************

.SUBCKT sg13cmos5l_nor4_1 Y A B C D VDD VSS
*.PININFO A:I B:I C:I D:I Y:O VDD:B VSS:B
MP0 net3 A VDD VDD sg13_lv_pmos m=1 w=1.12u l=130.00n ng=1
MP1 net2 B net3 VDD sg13_lv_pmos m=1 w=1.12u l=130.00n ng=1
MP2 net1 C net2 VDD sg13_lv_pmos m=1 w=1.12u l=130.00n ng=1
MP3 Y D net1 VDD sg13_lv_pmos m=1 w=1.12u l=130.00n ng=1
MN0 Y A VSS VSS sg13_lv_nmos m=1 w=740.00n l=130.00n ng=1
MN3 Y D VSS VSS sg13_lv_nmos m=1 w=740.00n l=130.00n ng=1
MN1 Y B VSS VSS sg13_lv_nmos m=1 w=740.00n l=130.00n ng=1
MN2 Y C VSS VSS sg13_lv_nmos m=1 w=740.00n l=130.00n ng=1
.ENDS

************************************************************************
* Library Name: sg13cmos5l_stdcell
* Cell Name:    sg13cmos5l_nor4_2
* View Name:    schematic
************************************************************************

.SUBCKT sg13cmos5l_nor4_2 Y A B C D VDD VSS
*.PININFO A:I B:I C:I D:I Y:O VDD:B VSS:B
MP0 net3 A VDD VDD sg13_lv_pmos m=1 w=2.24u l=130.00n ng=2
MP1 net2 B net3 VDD sg13_lv_pmos m=1 w=2.24u l=130.00n ng=2
MP2 net1 C net2 VDD sg13_lv_pmos m=1 w=2.24u l=130.00n ng=2
MP3 Y D net1 VDD sg13_lv_pmos m=1 w=2.24u l=130.00n ng=2
MN0 Y A VSS VSS sg13_lv_nmos m=1 w=1.48u l=130.00n ng=2
MN3 Y D VSS VSS sg13_lv_nmos m=1 w=1.48u l=130.00n ng=2
MN1 Y B VSS VSS sg13_lv_nmos m=1 w=1.48u l=130.00n ng=2
MN2 Y C VSS VSS sg13_lv_nmos m=1 w=1.48u l=130.00n ng=2
.ENDS

************************************************************************
* Library Name: sg13cmos5l_stdcell
* Cell Name:    sg13cmos5l_o21ai_1
* View Name:    schematic
************************************************************************

.SUBCKT sg13cmos5l_o21ai_1 Y A1 A2 B1 VDD VSS
*.PININFO A1:I A2:I B1:I Y:O VDD:B VSS:B
MP0 net14 A1 VDD VDD sg13_lv_pmos m=1 w=1.12u l=150.00n ng=1
MP1 Y A2 net14 VDD sg13_lv_pmos m=1 w=1.12u l=150.00n ng=1
MP2 Y B1 VDD VDD sg13_lv_pmos m=1 w=1.12u l=150.00n ng=1
MN0 net1 A2 VSS VSS sg13_lv_nmos m=1 w=740.00n l=150.00n ng=1
MN2 net1 A1 VSS VSS sg13_lv_nmos m=1 w=740.00n l=150.00n ng=1
MN1 Y B1 net1 VSS sg13_lv_nmos m=1 w=740.00n l=150.00n ng=1
.ENDS

************************************************************************
* Library Name: sg13cmos5l_stdcell
* Cell Name:    sg13cmos5l_or2_1
* View Name:    schematic
************************************************************************

.SUBCKT sg13cmos5l_or2_1 X A B VDD VSS
*.PININFO A:I B:I X:O VDD:B VSS:B
MP1 net2 B net3 VDD sg13_lv_pmos m=1 w=840.00n l=130.00n ng=1
MP0 net3 A VDD VDD sg13_lv_pmos m=1 w=840.00n l=130.00n ng=1
MP2 X net2 VDD VDD sg13_lv_pmos m=1 w=1.12u l=130.00n ng=1
MN1 net2 A VSS VSS sg13_lv_nmos m=1 w=550.00n l=130.00n ng=1
MN0 net2 B VSS VSS sg13_lv_nmos m=1 w=550.00n l=130.00n ng=1
MN2 X net2 VSS VSS sg13_lv_nmos m=1 w=740.00n l=130.00n ng=1
.ENDS

************************************************************************
* Library Name: sg13cmos5l_stdcell
* Cell Name:    sg13cmos5l_or2_2
* View Name:    schematic
************************************************************************

.SUBCKT sg13cmos5l_or2_2 X A B VDD VSS
*.PININFO A:I B:I X:O VDD:B VSS:B
MP1 net2 B net3 VDD sg13_lv_pmos m=1 w=840.00n l=130.00n ng=1
MP0 net3 A VDD VDD sg13_lv_pmos m=1 w=840.00n l=130.00n ng=1
MP2 X net2 VDD VDD sg13_lv_pmos m=1 w=2.24u l=130.00n ng=2
MN1 net2 A VSS VSS sg13_lv_nmos m=1 w=550.00n l=130.00n ng=1
MN0 net2 B VSS VSS sg13_lv_nmos m=1 w=550.00n l=130.00n ng=1
MN2 X net2 VSS VSS sg13_lv_nmos m=1 w=1.48u l=130.00n ng=2
.ENDS

************************************************************************
* Library Name: sg13cmos5l_stdcell
* Cell Name:    sg13cmos5l_or3_1
* View Name:    schematic
************************************************************************

.SUBCKT sg13cmos5l_or3_1 X A B C VDD VSS
*.PININFO A:I B:I C:I X:O VDD:B VSS:B
MN2 net1 C VSS VSS sg13_lv_nmos m=1 w=550.00n l=130.00n ng=1
MN3 X net1 VSS VSS sg13_lv_nmos m=1 w=740.00n l=130.00n ng=1
MN1 net1 B VSS VSS sg13_lv_nmos m=1 w=550.00n l=130.00n ng=1
MN0 net1 A VSS VSS sg13_lv_nmos m=1 w=550.00n l=130.00n ng=1
MP3 X net1 VDD VDD sg13_lv_pmos m=1 w=1.12u l=130.00n ng=1
MP1 net9 B net12 VDD sg13_lv_pmos m=1 w=1.000u l=130.00n ng=1
MP0 net12 A VDD VDD sg13_lv_pmos m=1 w=1.000u l=130.00n ng=1
MP2 net1 C net9 VDD sg13_lv_pmos m=1 w=1.000u l=130.00n ng=1
.ENDS

************************************************************************
* Library Name: sg13cmos5l_stdcell
* Cell Name:    sg13cmos5l_or3_2
* View Name:    schematic
************************************************************************

.SUBCKT sg13cmos5l_or3_2 X A B C VDD VSS
*.PININFO A:I B:I C:I X:O VDD:B VSS:B
MN2 net1 C VSS VSS sg13_lv_nmos m=1 w=550.00n l=130.00n ng=1
MN3 X net1 VSS VSS sg13_lv_nmos m=1 w=1.48u l=130.00n ng=2
MN1 net1 B VSS VSS sg13_lv_nmos m=1 w=550.00n l=130.00n ng=1
MN0 net1 A VSS VSS sg13_lv_nmos m=1 w=550.00n l=130.00n ng=1
MP3 X net1 VDD VDD sg13_lv_pmos m=1 w=2.24u l=130.00n ng=2
MP1 net9 B net12 VDD sg13_lv_pmos m=1 w=1.000u l=130.00n ng=1
MP0 net12 A VDD VDD sg13_lv_pmos m=1 w=1.000u l=130.00n ng=1
MP2 net1 C net9 VDD sg13_lv_pmos m=1 w=1.000u l=130.00n ng=1
.ENDS

************************************************************************
* Library Name: sg13cmos5l_stdcell
* Cell Name:    sg13cmos5l_or4_1
* View Name:    schematic
************************************************************************

.SUBCKT sg13cmos5l_or4_1 X A B C D VDD VSS
*.PININFO A:I B:I C:I D:I X:O VDD:B VSS:B
MN4 X net1 VSS VSS sg13_lv_nmos m=1 w=740.00n l=130.00n ng=1
MN3 net1 D VSS VSS sg13_lv_nmos m=1 w=550.00n l=130.00n ng=1
MN2 net1 C VSS VSS sg13_lv_nmos m=1 w=550.00n l=130.00n ng=1
MN1 net1 B VSS VSS sg13_lv_nmos m=1 w=550.00n l=130.00n ng=1
MN0 net1 A VSS VSS sg13_lv_nmos m=1 w=550.00n l=130.00n ng=1
MP0 net4 A VDD VDD sg13_lv_pmos m=1 w=1.000u l=130.00n ng=1
MP1 net3 B net4 VDD sg13_lv_pmos m=1 w=1.000u l=130.00n ng=1
MP2 net2 C net3 VDD sg13_lv_pmos m=1 w=1.000u l=130.00n ng=1
MP3 net1 D net2 VDD sg13_lv_pmos m=1 w=1.000u l=130.00n ng=1
MP4 X net1 VDD VDD sg13_lv_pmos m=1 w=1.12u l=130.00n ng=1
.ENDS

************************************************************************
* Library Name: sg13cmos5l_stdcell
* Cell Name:    sg13cmos5l_or4_2
* View Name:    schematic
************************************************************************

.SUBCKT sg13cmos5l_or4_2 X A B C D VDD VSS
*.PININFO A:I B:I C:I D:I X:O VDD:B VSS:B
MN4 X net1 VSS VSS sg13_lv_nmos m=1 w=1.48u l=130.00n ng=2
MN3 net1 D VSS VSS sg13_lv_nmos m=1 w=550.00n l=130.00n ng=1
MN2 net1 C VSS VSS sg13_lv_nmos m=1 w=550.00n l=130.00n ng=1
MN1 net1 B VSS VSS sg13_lv_nmos m=1 w=550.00n l=130.00n ng=1
MN0 net1 A VSS VSS sg13_lv_nmos m=1 w=550.00n l=130.00n ng=1
MP0 net4 A VDD VDD sg13_lv_pmos m=1 w=1.000u l=130.00n ng=1
MP1 net3 B net4 VDD sg13_lv_pmos m=1 w=1.000u l=130.00n ng=1
MP2 net2 C net3 VDD sg13_lv_pmos m=1 w=1.000u l=130.00n ng=1
MP3 net1 D net2 VDD sg13_lv_pmos m=1 w=1.000u l=130.00n ng=1
MP4 X net1 VDD VDD sg13_lv_pmos m=1 w=2.24u l=130.00n ng=2
.ENDS

************************************************************************
* Library Name: sg13cmos5l_stdcell
* Cell Name:    sg13cmos5l_sdfbbp_1
* View Name:    schematic
************************************************************************

.SUBCKT sg13cmos5l_sdfbbp_1 Q Q_N CLK D RESET_B SCD SCE SET_B VDD VSS
*.PININFO CLK:I D:I RESET_B:I SCD:I SCE:I SET_B:I Q:O Q_N:O VDD:B VSS:B
MP1 resetbb RESET_B VDD VDD sg13_lv_pmos m=1 w=640.00n l=130.00n ng=1
MP19 pre_q DbbLatch2 net8 VDD sg13_lv_pmos m=1 w=1.000u l=130.00n ng=1
MP20 pre_q SET_B VDD VDD sg13_lv_pmos m=1 w=1.000u l=130.00n ng=1
MP3 CLKbb CLKb VDD VDD sg13_lv_pmos m=1 w=1.12u l=130.00n ng=1
MP0 SCEb SCE VDD VDD sg13_lv_pmos m=1 w=640.00n l=130.00n ng=1
MP7 Db D net3 VDD sg13_lv_pmos m=1 w=640.00n l=130.00n ng=1
MP13 DbbTG CLKb net10 VDD sg13_lv_pmos m=1 w=420.00n l=130.00n ng=1
MP12 net10 DbLatchM VDD VDD sg13_lv_pmos m=1 w=420.00n l=130.00n ng=1
MP6 net3 SCE VDD VDD sg13_lv_pmos m=1 w=640.00n l=130.00n ng=1
MP21 Q_N pre_q VDD VDD sg13_lv_pmos m=1 w=1.12u l=130.00n ng=1
MP14 net1 DbLatchM VDD VDD sg13_lv_pmos m=1 w=840.00n l=130.00n ng=1
MP18 net8 resetbb VDD VDD sg13_lv_pmos m=1 w=1.000u l=130.00n ng=1
MP11 DbLatchM SET_B VDD VDD sg13_lv_pmos m=1 w=840.00n l=130.00n ng=1
MP4 net2 SCD VDD VDD sg13_lv_pmos m=1 w=640.00n l=130.00n ng=1
MP2 CLKb CLK VDD VDD sg13_lv_pmos m=1 w=1.12u l=130.00n ng=1
MP10 DbLatchM DbbTG net7 VDD sg13_lv_pmos m=1 w=840.00n l=130.00n ng=1
MP8 Db CLKbb DbbTG VDD sg13_lv_pmos m=1 w=640.00n l=130.00n ng=1
MP5 Db SCEb net2 VDD sg13_lv_pmos m=1 w=640.00n l=130.00n ng=1
MP22 pre_qb pre_q VDD VDD sg13_lv_pmos m=1 w=840.00n l=130.00n ng=1
MP9 net7 resetbb VDD VDD sg13_lv_pmos m=1 w=840.00n l=130.00n ng=1
MP16 net6 pre_q VDD VDD sg13_lv_pmos m=1 w=420.00n l=130.00n ng=1
MP17 DbbLatch2 CLKbb net6 VDD sg13_lv_pmos m=1 w=420.00n l=130.00n ng=1
MP15 DbbLatch2 CLKb net1 VDD sg13_lv_pmos m=1 w=840.00n l=130.00n ng=1
MP23 Q pre_qb VDD VDD sg13_lv_pmos m=1 w=1.12u l=130.00n ng=1
MN4 Db SCE net5 VSS sg13_lv_nmos m=1 w=420.00n l=130.00n ng=1
MN5 net5 SCD VSS VSS sg13_lv_nmos m=1 w=420.00n l=130.00n ng=1
MN18 pre_q DbbLatch2 net11 VSS sg13_lv_nmos m=1 w=740.00n l=130.00n ng=1
MN8 Db CLKb DbbTG VSS sg13_lv_nmos m=1 w=420.00n l=130.00n ng=1
MN7 net4 SCEb VSS VSS sg13_lv_nmos m=1 w=420.00n l=130.00n ng=1
MN3 CLKbb CLKb VSS VSS sg13_lv_nmos m=1 w=740.00n l=130.00n ng=1
MN1 resetbb RESET_B VSS VSS sg13_lv_nmos m=1 w=420.00n l=130.00n ng=1
MN17 net14 pre_q VSS VSS sg13_lv_nmos m=1 w=420.00n l=130.00n ng=1
MN9 DbLatchM DbbTG net12 VSS sg13_lv_nmos m=1 w=550.00n l=130.00n ng=1
MN0 SCEb SCE VSS VSS sg13_lv_nmos m=1 w=420.00n l=130.00n ng=1
MN10 net12 SET_B VSS VSS sg13_lv_nmos m=1 w=550.00n l=130.00n ng=1
MN13 net15 DbLatchM VSS VSS sg13_lv_nmos m=1 w=420.00n l=130.00n ng=1
MN19 net11 SET_B VSS VSS sg13_lv_nmos m=1 w=740.00n l=130.00n ng=1
MN12 DbbTG CLKbb net15 VSS sg13_lv_nmos m=1 w=420.00n l=130.00n ng=1
MN6 Db D net4 VSS sg13_lv_nmos m=1 w=420.00n l=130.00n ng=1
MN22 pre_qb pre_q VSS VSS sg13_lv_nmos m=1 w=550.00n l=130.00n ng=1
MN16 DbbLatch2 CLKb net14 VSS sg13_lv_nmos m=1 w=420.00n l=130.00n ng=1
MN23 Q pre_qb VSS VSS sg13_lv_nmos m=1 w=740.00n l=130.00n ng=1
MN15 net13 DbLatchM VSS VSS sg13_lv_nmos m=1 w=550.00n l=130.00n ng=1
MN2 CLKb CLK VSS VSS sg13_lv_nmos m=1 w=740.00n l=130.00n ng=1
MN14 DbbLatch2 CLKbb net13 VSS sg13_lv_nmos m=1 w=550.00n l=130.00n ng=1
MN11 DbLatchM resetbb net12 VSS sg13_lv_nmos m=1 w=550.00n l=130.00n ng=1
MN21 Q_N pre_q VSS VSS sg13_lv_nmos m=1 w=740.00n l=130.00n ng=1
MN20 pre_q resetbb net11 VSS sg13_lv_nmos m=1 w=740.00n l=130.00n ng=1
.ENDS

************************************************************************
* Library Name: sg13cmos5l_stdcell
* Cell Name:    sg13cmos5l_sighold
* View Name:    schematic
************************************************************************

.SUBCKT sg13cmos5l_sighold SH VDD VSS
*.PININFO SH:B VDD:B VSS:B
MN1 net1 SH VSS VSS sg13_lv_nmos m=1 w=300.0n l=130.00n ng=1
MN0 SH net1 VSS VSS sg13_lv_nmos m=1 w=300.0n l=700.0n ng=1
MP1 net1 SH VDD VDD sg13_lv_pmos m=1 w=450.00n l=130.00n ng=1
MP0 SH net1 VDD VDD sg13_lv_pmos m=1 w=300.0n l=700.0n ng=1
.ENDS

************************************************************************
* Library Name: sg13cmos5l_stdcell
* Cell Name:    sg13cmos5l_slgcp_1
* View Name:    schematic
************************************************************************

.SUBCKT sg13cmos5l_slgcp_1 GCLK CLK GATE SCE VDD VSS
*.PININFO CLK:I GATE:I SCE:I GCLK:O VDD:B VSS:B
MP10 GCLK net5 VDD VDD sg13_lv_pmos m=1 w=1.12u l=130.00n ng=1
MP4 net1 CLKbb net6 VDD sg13_lv_pmos m=1 w=840.00n l=130.00n ng=1
MP1 CLKbb CLKb VDD VDD sg13_lv_pmos m=1 w=840.00n l=130.00n ng=1
MP8 net5 int_GATE VDD VDD sg13_lv_pmos m=1 w=840.00n l=130.00n ng=1
MP2 net3 SCE VDD VDD sg13_lv_pmos m=1 w=840.00n l=130.00n ng=1
MP7 net6 CLKb net4 VDD sg13_lv_pmos m=1 w=420.00n l=130.00n ng=1
MP5 int_GATE net6 VDD VDD sg13_lv_pmos m=1 w=1.12u l=130.00n ng=1
MP0 CLKb CLK VDD VDD sg13_lv_pmos m=1 w=840.00n l=130.00n ng=1
MP9 net5 CLK VDD VDD sg13_lv_pmos m=1 w=840.00n l=130.00n ng=1
MP6 net4 int_GATE VDD VDD sg13_lv_pmos m=1 w=420.00n l=130.00n ng=1
MP3 net1 GATE net3 VDD sg13_lv_pmos m=1 w=840.00n l=130.00n ng=1
MN5 int_GATE net6 VSS VSS sg13_lv_nmos m=1 w=740.00n l=130.00n ng=1
MN9 net2 CLK VSS VSS sg13_lv_nmos m=1 w=640.00n l=130.00n ng=1
MN2 net1 SCE VSS VSS sg13_lv_nmos m=1 w=550.00n l=130.00n ng=1
MN4 net6 CLKb net1 VSS sg13_lv_nmos m=1 w=550.00n l=130.00n ng=1
MN7 net7 int_GATE VSS VSS sg13_lv_nmos m=1 w=420.00n l=130.00n ng=1
MN8 net5 int_GATE net2 VSS sg13_lv_nmos m=1 w=640.00n l=130.00n ng=1
MN10 GCLK net5 VSS VSS sg13_lv_nmos m=1 w=740.00n l=130.00n ng=1
MN1 CLKbb CLKb VSS VSS sg13_lv_nmos m=1 w=740.00n l=130.00n ng=1
MN3 net1 GATE VSS VSS sg13_lv_nmos m=1 w=550.00n l=130.00n ng=1
MN0 CLKb CLK VSS VSS sg13_lv_nmos m=1 w=740.00n l=130.00n ng=1
MN6 net6 CLKbb net7 VSS sg13_lv_nmos m=1 w=420.00n l=130.00n ng=1
.ENDS

************************************************************************
* Library Name: sg13cmos5l_stdcell
* Cell Name:    sg13cmos5l_tiehi
* View Name:    schematic
************************************************************************

.SUBCKT sg13cmos5l_tiehi L_HI VDD VSS
*.PININFO L_HI:O VDD:B VSS:B
MN1 net3 net2 VSS VSS sg13_lv_nmos m=1 w=795.00n l=130.00n ng=1
MN0 net1 net1 VSS VSS sg13_lv_nmos m=1 w=300n l=130.00n ng=1
MP1 L_HI net3 VDD VDD sg13_lv_pmos m=1 w=1.155u l=130.00n ng=1
MP0 net2 net1 VDD VDD sg13_lv_pmos m=1 w=660.0n l=130.00n ng=1
.ENDS

************************************************************************
* Library Name: sg13cmos5l_stdcell
* Cell Name:    sg13cmos5l_tielo
* View Name:    schematic
************************************************************************

.SUBCKT sg13cmos5l_tielo L_LO VDD VSS
*.PININFO L_LO:O VDD:B VSS:B
MN0 net3 net2 VSS VSS sg13_lv_nmos m=1 w=385.00n l=130.00n ng=1
MN1 L_LO net1 VSS VSS sg13_lv_nmos m=1 w=880.0n l=130.00n ng=1
MP0 net2 net2 VDD VDD sg13_lv_pmos m=1 w=300n l=130.00n ng=1
MP1 net1 net3 VDD VDD sg13_lv_pmos m=1 w=1.045u l=130.00n ng=1
.ENDS

************************************************************************
* Library Name: sg13cmos5l_stdcell
* Cell Name:    sg13cmos5l_xnor2_1
* View Name:    schematic
************************************************************************

.SUBCKT sg13cmos5l_xnor2_1 Y A B VDD VSS
*.PININFO A:I B:I Y:O VDD:B VSS:B
MP4 Y net1 VDD VDD sg13_lv_pmos m=1 w=1.12u l=130.00n ng=1
MP3 Y B net4 VDD sg13_lv_pmos m=1 w=1.12u l=130.00n ng=1
MP2 net4 A VDD VDD sg13_lv_pmos m=1 w=1.12u l=130.00n ng=1
MP1 net1 B VDD VDD sg13_lv_pmos m=1 w=840.00n l=130.00n ng=1
MP0 net1 A VDD VDD sg13_lv_pmos m=1 w=840.00n l=130.00n ng=1
MN3 Y net1 net3 VSS sg13_lv_nmos m=1 w=740.00n l=130.00n ng=1
MN1 net2 A VSS VSS sg13_lv_nmos m=1 w=640.00n l=130.00n ng=1
MN0 net1 B net2 VSS sg13_lv_nmos m=1 w=640.00n l=130.00n ng=1
MN4 net3 B VSS VSS sg13_lv_nmos m=1 w=740.00n l=130.00n ng=1
MN2 net3 A VSS VSS sg13_lv_nmos m=1 w=740.00n l=130.00n ng=1
.ENDS

************************************************************************
* Library Name: sg13cmos5l_stdcell
* Cell Name:    sg13cmos5l_xor2_1
* View Name:    schematic
************************************************************************

.SUBCKT sg13cmos5l_xor2_1 X A B VDD VSS
*.PININFO A:I B:I X:O VDD:B VSS:B
MN0 net1 A VSS VSS sg13_lv_nmos m=1 w=550.00n l=130.00n ng=1
MN3 X B net3 VSS sg13_lv_nmos m=1 w=740.00n l=130.00n ng=1
MN2 X net1 VSS VSS sg13_lv_nmos m=1 w=740.00n l=130.00n ng=1
MN4 net3 A VSS VSS sg13_lv_nmos m=1 w=740.00n l=130.00n ng=1
MN1 net1 B VSS VSS sg13_lv_nmos m=1 w=550.00n l=130.00n ng=1
MP0 net6 A VDD VDD sg13_lv_pmos m=1 w=1.000u l=130.00n ng=1
MP1 net1 B net6 VDD sg13_lv_pmos m=1 w=1.000u l=130.00n ng=1
MP2 net5 A VDD VDD sg13_lv_pmos m=1 w=1.12u l=130.00n ng=1
MP4 net5 B VDD VDD sg13_lv_pmos m=1 w=1.12u l=130.00n ng=1
MP3 X net1 net5 VDD sg13_lv_pmos m=1 w=1.12u l=130.00n ng=1
.ENDS

************************************************************************
* Library Name: sg13cmos5l_stdcell
* Cell Name:    sg13cmos5l_a22oi_1
* View Name:    schematic
************************************************************************

.SUBCKT sg13cmos5l_a22oi_1 Y A1 A2 B1 B2 VDD VSS
*.PININFO A1:I A2:I B1:I B2:I Y:O VDD:B VSS:B
MN1 net1 B1 VSS VSS sg13_lv_nmos m=1 w=740.00n l=130.00n ng=1
MN0 Y B2 net1 VSS sg13_lv_nmos m=1 w=740.00n l=130.00n ng=1
MN3 net2 A2 VSS VSS sg13_lv_nmos m=1 w=740.00n l=130.00n ng=1
MN2 Y A1 net2 VSS sg13_lv_nmos m=1 w=740.00n l=130.00n ng=1
MP1 Y B1 net3 VDD sg13_lv_pmos m=1 w=1.12u l=130.00n ng=1
MP3 Y B2 net3 VDD sg13_lv_pmos m=1 w=1.12u l=130.00n ng=1
MP2 net3 A2 VDD VDD sg13_lv_pmos m=1 w=1.12u l=130.00n ng=1
MP0 net3 A1 VDD VDD sg13_lv_pmos m=1 w=1.12u l=130.00n ng=1
.ENDS

************************************************************************
* Library Name: sg13cmos5l_stdcell
* Cell Name:    sg13cmos5l_sdfrbpq_1
* View Name:    schematic
************************************************************************

.SUBCKT sg13cmos5l_sdfrbpq_1 Q CLK D RESET_B SCD SCE VDD VSS
*.PININFO CLK:I D:I RESET_B:I SCD:I SCE:I Q:O VDD:B VSS:B
MN3 Db SCD net63 VSS sg13_lv_nmos m=1 w=740.00n l=130.00n ng=1
MN1 Db D net65 VSS sg13_lv_nmos m=1 w=740.00n l=130.00n ng=1
MN0 SCEb SCE VSS VSS sg13_lv_nmos m=1 w=550.00n l=130.00n ng=1
MN4 net63 SCE VSS VSS sg13_lv_nmos m=1 w=740.00n l=130.00n ng=1
MN2 net65 SCEb VSS VSS sg13_lv_nmos m=1 w=740.00n l=130.00n ng=1
MN17 net12 net2 VSS VSS sg13_lv_nmos m=1 w=420.00n l=130.00n ng=1
MN16 net5 clkneg net12 VSS sg13_lv_nmos m=1 w=420.00n l=130.00n ng=1
MN18 net2 net5 net11 VSS sg13_lv_nmos m=1 w=420.00n l=130.00n ng=1
MN19 net11 RESET_B VSS VSS sg13_lv_nmos m=1 w=420.00n l=130.00n ng=1
MN20 Q net2 VSS VSS sg13_lv_nmos m=1 w=740.00n l=130.00n ng=1
MN6 Dbbb Dbb net10 VSS sg13_lv_nmos m=1 w=420.00n l=130.00n ng=1
MN7 net10 RESET_B VSS VSS sg13_lv_nmos m=1 w=420.00n l=130.00n ng=1
MN10 Dbbb clkneg net6 VSS sg13_lv_nmos m=1 w=420.00n l=130.00n ng=1
MN11 net6 clkpos net9 VSS sg13_lv_nmos m=1 w=420.00n l=130.00n ng=1
MN12 net9 net4 net8 VSS sg13_lv_nmos m=1 w=420.00n l=130.00n ng=1
MN13 net8 RESET_B VSS VSS sg13_lv_nmos m=1 w=420.00n l=130.00n ng=1
MN14 net4 net6 VSS VSS sg13_lv_nmos m=1 w=740.00n l=130.00n ng=1
MN8 clkneg CLK VSS VSS sg13_lv_nmos m=1 w=740.00n l=130.00n ng=1
MN15 net4 clkpos net5 VSS sg13_lv_nmos m=1 w=740.00n l=130.00n ng=1
MN9 clkpos clkneg VSS VSS sg13_lv_nmos m=1 w=740.00n l=130.00n ng=1
MN5 Dbb Db VSS VSS sg13_lv_nmos m=1 w=740.00n l=130.00n ng=1
MP1 net64 SCE VDD VDD sg13_lv_pmos m=1 w=1.000u l=130.00n ng=1
MP3 net62 SCEb VDD VDD sg13_lv_pmos m=1 w=1.000u l=130.00n ng=1
MP0 SCEb SCE VDD VDD sg13_lv_pmos m=1 w=840.00n l=130.00n ng=1
MP4 Db SCD net62 VDD sg13_lv_pmos m=1 w=1.000u l=130.00n ng=1
MP2 Db D net64 VDD sg13_lv_pmos m=1 w=1.000u l=130.00n ng=1
MP17 net5 clkpos net3 VDD sg13_lv_pmos m=1 w=420.00n l=130.00n ng=1
MP18 net2 net5 VDD VDD sg13_lv_pmos m=1 w=420.00n l=130.00n ng=1
MP19 net2 RESET_B VDD VDD sg13_lv_pmos m=1 w=420.00n l=130.00n ng=1
MP20 Q net2 VDD VDD sg13_lv_pmos m=1 w=1.12u l=130.00n ng=1
MP10 Dbbb clkpos net6 VDD sg13_lv_pmos m=1 w=420.00n l=130.00n ng=1
MP6 Dbbb RESET_B VDD VDD sg13_lv_pmos m=1 w=420.00n l=130.00n ng=1
MP7 Dbbb Dbb VDD VDD sg13_lv_pmos m=1 w=420.00n l=130.00n ng=1
MP11 net7 net4 VDD VDD sg13_lv_pmos m=1 w=420.00n l=130.00n ng=1
MP12 net6 clkneg net7 VDD sg13_lv_pmos m=1 w=420.00n l=130.00n ng=1
MP13 net6 RESET_B VDD VDD sg13_lv_pmos m=1 w=420.00n l=130.00n ng=1
MP8 clkneg CLK VDD VDD sg13_lv_pmos m=1 w=1.12u l=130.00n ng=1
MP9 clkpos clkneg VDD VDD sg13_lv_pmos m=1 w=1.12u l=130.00n ng=1
MP14 net4 net6 VDD VDD sg13_lv_pmos m=1 w=1.000u l=130.00n ng=1
MP15 net4 clkneg net5 VDD sg13_lv_pmos m=1 w=1.000u l=130.00n ng=1
MP5 Dbb Db VDD VDD sg13_lv_pmos m=1 w=1.12u l=130.00n ng=1
MP16 net3 net2 VDD VDD sg13_lv_pmos m=1 w=420.00n l=130.00n ng=1
.ENDS

************************************************************************
* Library Name: sg13cmos5l_stdcell
* Cell Name:    sg13cmos5l_sdfrbpq_2
* View Name:    schematic
************************************************************************

.SUBCKT sg13cmos5l_sdfrbpq_2 Q CLK D RESET_B SCD SCE VDD VSS
*.PININFO CLK:I D:I RESET_B:I SCD:I SCE:I Q:O VDD:B VSS:B
MN3 Db SCD net63 VSS sg13_lv_nmos m=1 w=740.00n l=130.00n ng=1
MN1 Db D net65 VSS sg13_lv_nmos m=1 w=740.00n l=130.00n ng=1
MN0 SCEb SCE VSS VSS sg13_lv_nmos m=1 w=550.00n l=130.00n ng=1
MN4 net63 SCE VSS VSS sg13_lv_nmos m=1 w=740.00n l=130.00n ng=1
MN2 net65 SCEb VSS VSS sg13_lv_nmos m=1 w=740.00n l=130.00n ng=1
MN5 Dbb Db VSS VSS sg13_lv_nmos m=1 w=740.00n l=130.00n ng=1
MN17 net12 net2 VSS VSS sg13_lv_nmos m=1 w=420.00n l=130.00n ng=1
MN16 net5 clkneg net12 VSS sg13_lv_nmos m=1 w=420.00n l=130.00n ng=1
MN18 net2 net5 net11 VSS sg13_lv_nmos m=1 w=420.00n l=130.00n ng=1
MN19 net11 RESET_B VSS VSS sg13_lv_nmos m=1 w=420.00n l=130.00n ng=1
MN20 Q net2 VSS VSS sg13_lv_nmos m=1 w=1.48u l=130.00n ng=2
MN6 Dbbb Dbb net10 VSS sg13_lv_nmos m=1 w=420.00n l=130.00n ng=1
MN7 net10 RESET_B VSS VSS sg13_lv_nmos m=1 w=420.00n l=130.00n ng=1
MN10 Dbbb clkneg net6 VSS sg13_lv_nmos m=1 w=420.00n l=130.00n ng=1
MN11 net6 clkpos net9 VSS sg13_lv_nmos m=1 w=420.00n l=130.00n ng=1
MN12 net9 net4 net8 VSS sg13_lv_nmos m=1 w=420.00n l=130.00n ng=1
MN13 net8 RESET_B VSS VSS sg13_lv_nmos m=1 w=420.00n l=130.00n ng=1
MN14 net4 net6 VSS VSS sg13_lv_nmos m=1 w=740.00n l=130.00n ng=1
MN8 clkneg CLK VSS VSS sg13_lv_nmos m=1 w=740.00n l=130.00n ng=1
MN15 net4 clkpos net5 VSS sg13_lv_nmos m=1 w=740.00n l=130.00n ng=1
MN9 clkpos clkneg VSS VSS sg13_lv_nmos m=1 w=740.00n l=130.00n ng=1
MP1 net64 SCE VDD VDD sg13_lv_pmos m=1 w=1.000u l=130.00n ng=1
MP3 net62 SCEb VDD VDD sg13_lv_pmos m=1 w=1.000u l=130.00n ng=1
MP0 SCEb SCE VDD VDD sg13_lv_pmos m=1 w=840.00n l=130.00n ng=1
MP4 Db SCD net62 VDD sg13_lv_pmos m=1 w=1.000u l=130.00n ng=1
MP2 Db D net64 VDD sg13_lv_pmos m=1 w=1.000u l=130.00n ng=1
MP5 Dbb Db VDD VDD sg13_lv_pmos m=1 w=1.12u l=130.00n ng=1
MP17 net5 clkpos net3 VDD sg13_lv_pmos m=1 w=420.00n l=130.00n ng=1
MP18 net2 net5 VDD VDD sg13_lv_pmos m=1 w=420.00n l=130.00n ng=1
MP19 net2 RESET_B VDD VDD sg13_lv_pmos m=1 w=420.00n l=130.00n ng=1
MP20 Q net2 VDD VDD sg13_lv_pmos m=1 w=2.24u l=130.00n ng=2
MP10 Dbbb clkpos net6 VDD sg13_lv_pmos m=1 w=420.00n l=130.00n ng=1
MP6 Dbbb RESET_B VDD VDD sg13_lv_pmos m=1 w=420.00n l=130.00n ng=1
MP7 Dbbb Dbb VDD VDD sg13_lv_pmos m=1 w=420.00n l=130.00n ng=1
MP11 net7 net4 VDD VDD sg13_lv_pmos m=1 w=420.00n l=130.00n ng=1
MP12 net6 clkneg net7 VDD sg13_lv_pmos m=1 w=420.00n l=130.00n ng=1
MP13 net6 RESET_B VDD VDD sg13_lv_pmos m=1 w=420.00n l=130.00n ng=1
MP8 clkneg CLK VDD VDD sg13_lv_pmos m=1 w=1.12u l=130.00n ng=1
MP9 clkpos clkneg VDD VDD sg13_lv_pmos m=1 w=1.12u l=130.00n ng=1
MP14 net4 net6 VDD VDD sg13_lv_pmos m=1 w=1.000u l=130.00n ng=1
MP15 net4 clkneg net5 VDD sg13_lv_pmos m=1 w=1.000u l=130.00n ng=1
MP16 net3 net2 VDD VDD sg13_lv_pmos m=1 w=420.00n l=130.00n ng=1
.ENDS

************************************************************************
* Library Name: sg13cmos5l_stdcell
* Cell Name:    sg13cmos5l_sdfrbp_2
* View Name:    schematic
************************************************************************

.SUBCKT sg13cmos5l_sdfrbp_2 Q Q_N CLK D RESET_B SCD SCE VDD VSS
*.PININFO CLK:I D:I RESET_B:I SCD:I SCE:I Q:O Q_N:O VDD:B VSS:B
MN3 Db SCD net63 VSS sg13_lv_nmos m=1 w=740.00n l=130.00n ng=1
MN1 Db D net65 VSS sg13_lv_nmos m=1 w=740.00n l=130.00n ng=1
MN0 SCEb SCE VSS VSS sg13_lv_nmos m=1 w=550.00n l=130.00n ng=1
MN4 net63 SCE VSS VSS sg13_lv_nmos m=1 w=740.00n l=130.00n ng=1
MN2 net65 SCEb VSS VSS sg13_lv_nmos m=1 w=740.00n l=130.00n ng=1
MN5 Dbb Db VSS VSS sg13_lv_nmos m=1 w=740.00n l=130.00n ng=1
MN17 net12 net2 VSS VSS sg13_lv_nmos m=1 w=420.00n l=130.00n ng=1
MN16 net5 clkneg net12 VSS sg13_lv_nmos m=1 w=420.00n l=130.00n ng=1
MN18 net2 net5 net11 VSS sg13_lv_nmos m=1 w=420.00n l=130.00n ng=1
MN19 net11 RESET_B VSS VSS sg13_lv_nmos m=1 w=420.00n l=130.00n ng=1
MN20 Q_N net5 VSS VSS sg13_lv_nmos m=1 w=1.48u l=130.00n ng=2
MN6 Dbbb Dbb net10 VSS sg13_lv_nmos m=1 w=420.00n l=130.00n ng=1
MN7 net10 RESET_B VSS VSS sg13_lv_nmos m=1 w=420.00n l=130.00n ng=1
MN10 Dbbb clkneg net6 VSS sg13_lv_nmos m=1 w=420.00n l=130.00n ng=1
MN11 net6 clkpos net9 VSS sg13_lv_nmos m=1 w=420.00n l=130.00n ng=1
MN12 net9 net4 net8 VSS sg13_lv_nmos m=1 w=420.00n l=130.00n ng=1
MN13 net8 RESET_B VSS VSS sg13_lv_nmos m=1 w=420.00n l=130.00n ng=1
MN14 net4 net6 VSS VSS sg13_lv_nmos m=1 w=740.00n l=130.00n ng=1
MN8 clkneg CLK VSS VSS sg13_lv_nmos m=1 w=740.00n l=130.00n ng=1
MN15 net4 clkpos net5 VSS sg13_lv_nmos m=1 w=740.00n l=130.00n ng=1
MN9 clkpos clkneg VSS VSS sg13_lv_nmos m=1 w=740.00n l=130.00n ng=1
MN22 Q net1 VSS VSS sg13_lv_nmos m=1 w=1.48u l=130.00n ng=2
MN21 net1 net5 VSS VSS sg13_lv_nmos m=1 w=640.00n l=130.00n ng=1
MP1 net64 SCE VDD VDD sg13_lv_pmos m=1 w=1.000u l=130.00n ng=1
MP3 net62 SCEb VDD VDD sg13_lv_pmos m=1 w=1.000u l=130.00n ng=1
MP0 SCEb SCE VDD VDD sg13_lv_pmos m=1 w=840.00n l=130.00n ng=1
MP4 Db SCD net62 VDD sg13_lv_pmos m=1 w=1.000u l=130.00n ng=1
MP2 Db D net64 VDD sg13_lv_pmos m=1 w=1.000u l=130.00n ng=1
MP5 Dbb Db VDD VDD sg13_lv_pmos m=1 w=1.12u l=130.00n ng=1
MP17 net5 clkpos net3 VDD sg13_lv_pmos m=1 w=420.00n l=130.00n ng=1
MP18 net2 net5 VDD VDD sg13_lv_pmos m=1 w=420.00n l=130.00n ng=1
MP19 net2 RESET_B VDD VDD sg13_lv_pmos m=1 w=420.00n l=130.00n ng=1
MP20 Q_N net5 VDD VDD sg13_lv_pmos m=1 w=2.24u l=130.00n ng=2
MP10 Dbbb clkpos net6 VDD sg13_lv_pmos m=1 w=420.00n l=130.00n ng=1
MP6 Dbbb RESET_B VDD VDD sg13_lv_pmos m=1 w=420.00n l=130.00n ng=1
MP7 Dbbb Dbb VDD VDD sg13_lv_pmos m=1 w=420.00n l=130.00n ng=1
MP11 net7 net4 VDD VDD sg13_lv_pmos m=1 w=420.00n l=130.00n ng=1
MP12 net6 clkneg net7 VDD sg13_lv_pmos m=1 w=420.00n l=130.00n ng=1
MP13 net6 RESET_B VDD VDD sg13_lv_pmos m=1 w=420.00n l=130.00n ng=1
MP8 clkneg CLK VDD VDD sg13_lv_pmos m=1 w=1.12u l=130.00n ng=1
MP9 clkpos clkneg VDD VDD sg13_lv_pmos m=1 w=1.12u l=130.00n ng=1
MP14 net4 net6 VDD VDD sg13_lv_pmos m=1 w=1.000u l=130.00n ng=1
MP15 net4 clkneg net5 VDD sg13_lv_pmos m=1 w=1.000u l=130.00n ng=1
MP22 Q net1 VDD VDD sg13_lv_pmos m=1 w=2.24u l=130.00n ng=2
MP16 net3 net2 VDD VDD sg13_lv_pmos m=1 w=420.00n l=130.00n ng=1
MP21 net1 net5 VDD VDD sg13_lv_pmos m=1 w=1.000u l=130.00n ng=1
.ENDS

************************************************************************
* Library Name: sg13cmos5l_stdcell
* Cell Name:    sg13cmos5l_sdfrbp_1
* View Name:    schematic
************************************************************************

.SUBCKT sg13cmos5l_sdfrbp_1 Q Q_N CLK D RESET_B SCD SCE VDD VSS
*.PININFO CLK:I D:I RESET_B:I SCD:I SCE:I Q:O Q_N:O VDD:B VSS:B
MN3 Db SCD net63 VSS sg13_lv_nmos m=1 w=740.00n l=130.00n ng=1
MN1 Db D net65 VSS sg13_lv_nmos m=1 w=740.00n l=130.00n ng=1
MN0 SCEb SCE VSS VSS sg13_lv_nmos m=1 w=550.00n l=130.00n ng=1
MN4 net63 SCE VSS VSS sg13_lv_nmos m=1 w=740.00n l=130.00n ng=1
MN2 net65 SCEb VSS VSS sg13_lv_nmos m=1 w=740.00n l=130.00n ng=1
MN5 net13 Db VSS VSS sg13_lv_nmos m=1 w=740.00n l=130.00n ng=1
MN17 net12 net2 VSS VSS sg13_lv_nmos m=1 w=420.00n l=130.00n ng=1
MN16 net5 clkneg net12 VSS sg13_lv_nmos m=1 w=420.00n l=130.00n ng=1
MN18 net2 net5 net11 VSS sg13_lv_nmos m=1 w=420.00n l=130.00n ng=1
MN19 net11 RESET_B VSS VSS sg13_lv_nmos m=1 w=420.00n l=130.00n ng=1
MN20 Q_N net5 VSS VSS sg13_lv_nmos m=1 w=740.00n l=130.00n ng=1
MN6 Dbb net13 net10 VSS sg13_lv_nmos m=1 w=420.00n l=130.00n ng=1
MN7 net10 RESET_B VSS VSS sg13_lv_nmos m=1 w=420.00n l=130.00n ng=1
MN10 Dbb clkneg net6 VSS sg13_lv_nmos m=1 w=420.00n l=130.00n ng=1
MN11 net6 clkpos net9 VSS sg13_lv_nmos m=1 w=420.00n l=130.00n ng=1
MN12 net9 net4 net8 VSS sg13_lv_nmos m=1 w=420.00n l=130.00n ng=1
MN13 net8 RESET_B VSS VSS sg13_lv_nmos m=1 w=420.00n l=130.00n ng=1
MN14 net4 net6 VSS VSS sg13_lv_nmos m=1 w=740.00n l=130.00n ng=1
MN8 clkneg CLK VSS VSS sg13_lv_nmos m=1 w=740.00n l=130.00n ng=1
MN15 net4 clkpos net5 VSS sg13_lv_nmos m=1 w=740.00n l=130.00n ng=1
MN9 clkpos clkneg VSS VSS sg13_lv_nmos m=1 w=740.00n l=130.00n ng=1
MN22 Q net1 VSS VSS sg13_lv_nmos m=1 w=740.00n l=130.00n ng=1
MN21 net1 net5 VSS VSS sg13_lv_nmos m=1 w=640.00n l=130.00n ng=1
MP1 net64 SCE VDD VDD sg13_lv_pmos m=1 w=1.000u l=130.00n ng=1
MP3 net62 SCEb VDD VDD sg13_lv_pmos m=1 w=1.000u l=130.00n ng=1
MP0 SCEb SCE VDD VDD sg13_lv_pmos m=1 w=840.00n l=130.00n ng=1
MP4 Db SCD net62 VDD sg13_lv_pmos m=1 w=1.000u l=130.00n ng=1
MP2 Db D net64 VDD sg13_lv_pmos m=1 w=1.000u l=130.00n ng=1
MP5 net13 Db VDD VDD sg13_lv_pmos m=1 w=1.12u l=130.00n ng=1
MP17 net5 clkpos net3 VDD sg13_lv_pmos m=1 w=420.00n l=130.00n ng=1
MP18 net2 net5 VDD VDD sg13_lv_pmos m=1 w=420.00n l=130.00n ng=1
MP19 net2 RESET_B VDD VDD sg13_lv_pmos m=1 w=420.00n l=130.00n ng=1
MP20 Q_N net5 VDD VDD sg13_lv_pmos m=1 w=1.12u l=130.00n ng=1
MP10 Dbb clkpos net6 VDD sg13_lv_pmos m=1 w=420.00n l=130.00n ng=1
MP6 Dbb RESET_B VDD VDD sg13_lv_pmos m=1 w=420.00n l=130.00n ng=1
MP7 Dbb net13 VDD VDD sg13_lv_pmos m=1 w=420.00n l=130.00n ng=1
MP11 net7 net4 VDD VDD sg13_lv_pmos m=1 w=420.00n l=130.00n ng=1
MP12 net6 clkneg net7 VDD sg13_lv_pmos m=1 w=420.00n l=130.00n ng=1
MP13 net6 RESET_B VDD VDD sg13_lv_pmos m=1 w=420.00n l=130.00n ng=1
MP8 clkneg CLK VDD VDD sg13_lv_pmos m=1 w=1.12u l=130.00n ng=1
MP9 clkpos clkneg VDD VDD sg13_lv_pmos m=1 w=1.12u l=130.00n ng=1
MP14 net4 net6 VDD VDD sg13_lv_pmos m=1 w=1.000u l=130.00n ng=1
MP15 net4 clkneg net5 VDD sg13_lv_pmos m=1 w=1.000u l=130.00n ng=1
MP22 Q net1 VDD VDD sg13_lv_pmos m=1 w=1.12u l=130.00n ng=1
MP16 net3 net2 VDD VDD sg13_lv_pmos m=1 w=420.00n l=130.00n ng=1
MP21 net1 net5 VDD VDD sg13_lv_pmos m=1 w=1.000u l=130.00n ng=1
.ENDS

************************************************************************
* Library Name: sg13cmos5l_stdcell
* Cell Name:    sg13cmos5l_dfrbpq_2
* View Name:    schematic
************************************************************************

.SUBCKT sg13cmos5l_dfrbpq_2 Q CLK D RESET_B VDD VSS
*.PININFO CLK:I D:I RESET_B:I Q:O VDD:B VSS:B
MN11 net12 net2 VSS VSS sg13_lv_nmos m=1 w=420.00n l=130.00n ng=1
MN10 net5 clkneg net12 VSS sg13_lv_nmos m=1 w=420.00n l=130.00n ng=1
MN12 net2 net5 net11 VSS sg13_lv_nmos m=1 w=420.00n l=130.00n ng=1
MN13 net11 RESET_B VSS VSS sg13_lv_nmos m=1 w=420.00n l=130.00n ng=1
MN0 Db D net10 VSS sg13_lv_nmos m=1 w=420.00n l=130.00n ng=1
MN1 net10 RESET_B VSS VSS sg13_lv_nmos m=1 w=420.00n l=130.00n ng=1
MN4 Db clkneg net6 VSS sg13_lv_nmos m=1 w=420.00n l=130.00n ng=1
MN5 net6 clkpos net9 VSS sg13_lv_nmos m=1 w=420.00n l=130.00n ng=1
MN6 net9 net4 net8 VSS sg13_lv_nmos m=1 w=420.00n l=130.00n ng=1
MN7 net8 RESET_B VSS VSS sg13_lv_nmos m=1 w=420.00n l=130.00n ng=1
MN8 net4 net6 VSS VSS sg13_lv_nmos m=1 w=740.00n l=130.00n ng=1
MN2 clkneg CLK VSS VSS sg13_lv_nmos m=1 w=740.00n l=130.00n ng=1
MN9 net4 clkpos net5 VSS sg13_lv_nmos m=1 w=740.00n l=130.00n ng=1
MN3 clkpos clkneg VSS VSS sg13_lv_nmos m=1 w=740.00n l=130.00n ng=1
MN15 Q net1 VSS VSS sg13_lv_nmos m=1 w=1.48u l=130.00n ng=2
MN14 net1 net5 VSS VSS sg13_lv_nmos m=1 w=640.00n l=130.00n ng=1
MP11 net5 clkpos net3 VDD sg13_lv_pmos m=1 w=420.00n l=130.00n ng=1
MP12 net2 net5 VDD VDD sg13_lv_pmos m=1 w=420.00n l=130.00n ng=1
MP13 net2 RESET_B VDD VDD sg13_lv_pmos m=1 w=420.00n l=130.00n ng=1
MP4 Db clkpos net6 VDD sg13_lv_pmos m=1 w=420.00n l=130.00n ng=1
MP0 Db RESET_B VDD VDD sg13_lv_pmos m=1 w=420.00n l=130.00n ng=1
MP1 Db D VDD VDD sg13_lv_pmos m=1 w=420.00n l=130.00n ng=1
MP5 net7 net4 VDD VDD sg13_lv_pmos m=1 w=420.00n l=130.00n ng=1
MP6 net6 clkneg net7 VDD sg13_lv_pmos m=1 w=420.00n l=130.00n ng=1
MP7 net6 RESET_B VDD VDD sg13_lv_pmos m=1 w=420.00n l=130.00n ng=1
MP2 clkneg CLK VDD VDD sg13_lv_pmos m=1 w=1.12u l=130.00n ng=1
MP3 clkpos clkneg VDD VDD sg13_lv_pmos m=1 w=1.12u l=130.00n ng=1
MP8 net4 net6 VDD VDD sg13_lv_pmos m=1 w=1.000u l=130.00n ng=1
MP9 net4 clkneg net5 VDD sg13_lv_pmos m=1 w=1.000u l=130.00n ng=1
MP15 Q net1 VDD VDD sg13_lv_pmos m=1 w=2.24u l=130.00n ng=2
MP10 net3 net2 VDD VDD sg13_lv_pmos m=1 w=420.00n l=130.00n ng=1
MP14 net1 net5 VDD VDD sg13_lv_pmos m=1 w=1.000u l=130.00n ng=1
.ENDS

************************************************************************
* Library Name: sg13cmos5l_stdcell
* Cell Name:    sg13cmos5l_dfrbpq_1
* View Name:    schematic
************************************************************************

.SUBCKT sg13cmos5l_dfrbpq_1 Q CLK D RESET_B VDD VSS
*.PININFO CLK:I D:I RESET_B:I Q:O VDD:B VSS:B
MN11 net12 net2 VSS VSS sg13_lv_nmos m=1 w=420.00n l=130.00n ng=1
MN10 net5 clkneg net12 VSS sg13_lv_nmos m=1 w=420.00n l=130.00n ng=1
MN12 net2 net5 net11 VSS sg13_lv_nmos m=1 w=420.00n l=130.00n ng=1
MN13 net11 RESET_B VSS VSS sg13_lv_nmos m=1 w=420.00n l=130.00n ng=1
MN0 Db D net10 VSS sg13_lv_nmos m=1 w=420.00n l=130.00n ng=1
MN1 net10 RESET_B VSS VSS sg13_lv_nmos m=1 w=420.00n l=130.00n ng=1
MN4 Db clkneg net6 VSS sg13_lv_nmos m=1 w=420.00n l=130.00n ng=1
MN5 net6 clkpos net9 VSS sg13_lv_nmos m=1 w=420.00n l=130.00n ng=1
MN6 net9 net4 net8 VSS sg13_lv_nmos m=1 w=420.00n l=130.00n ng=1
MN7 net8 RESET_B VSS VSS sg13_lv_nmos m=1 w=420.00n l=130.00n ng=1
MN8 net4 net6 VSS VSS sg13_lv_nmos m=1 w=740.00n l=130.00n ng=1
MN2 clkneg CLK VSS VSS sg13_lv_nmos m=1 w=740.00n l=130.00n ng=1
MN9 net4 clkpos net5 VSS sg13_lv_nmos m=1 w=740.00n l=130.00n ng=1
MN3 clkpos clkneg VSS VSS sg13_lv_nmos m=1 w=740.00n l=130.00n ng=1
MN15 Q net1 VSS VSS sg13_lv_nmos m=1 w=740.00n l=130.00n ng=1
MN14 net1 net5 VSS VSS sg13_lv_nmos m=1 w=740.00n l=130.00n ng=1
MP11 net5 clkpos net3 VDD sg13_lv_pmos m=1 w=420.00n l=130.00n ng=1
MP12 net2 net5 VDD VDD sg13_lv_pmos m=1 w=420.00n l=130.00n ng=1
MP13 net2 RESET_B VDD VDD sg13_lv_pmos m=1 w=420.00n l=130.00n ng=1
MP4 Db clkpos net6 VDD sg13_lv_pmos m=1 w=420.00n l=130.00n ng=1
MP0 Db RESET_B VDD VDD sg13_lv_pmos m=1 w=420.00n l=130.00n ng=1
MP1 Db D VDD VDD sg13_lv_pmos m=1 w=420.00n l=130.00n ng=1
MP5 net7 net4 VDD VDD sg13_lv_pmos m=1 w=420.00n l=130.00n ng=1
MP6 net6 clkneg net7 VDD sg13_lv_pmos m=1 w=420.00n l=130.00n ng=1
MP7 net6 RESET_B VDD VDD sg13_lv_pmos m=1 w=420.00n l=130.00n ng=1
MP2 clkneg CLK VDD VDD sg13_lv_pmos m=1 w=1.12u l=130.00n ng=1
MP3 clkpos clkneg VDD VDD sg13_lv_pmos m=1 w=1.12u l=130.00n ng=1
MP8 net4 net6 VDD VDD sg13_lv_pmos m=1 w=1.000u l=130.00n ng=1
MP9 net4 clkneg net5 VDD sg13_lv_pmos m=1 w=1.000u l=130.00n ng=1
MP15 Q net1 VDD VDD sg13_lv_pmos m=1 w=1.12u l=130.00n ng=1
MP10 net3 net2 VDD VDD sg13_lv_pmos m=1 w=420.00n l=130.00n ng=1
MP14 net1 net5 VDD VDD sg13_lv_pmos m=1 w=1.12u l=130.00n ng=1
.ENDS

************************************************************************
* Library Name: sg13cmos5l_stdcell
* Cell Name:    sg13cmos5l_fill_1
* View Name:    schematic
************************************************************************

.SUBCKT sg13cmos5l_fill_1 VDD VSS
*.PININFO VDD:B VSS:B
.ENDS

************************************************************************
* Library Name: sg13cmos5l_stdcell
* Cell Name:    sg13cmos5l_fill_2
* View Name:    schematic
************************************************************************

.SUBCKT sg13cmos5l_fill_2 VDD VSS
*.PININFO VDD:B VSS:B
.ENDS

************************************************************************
* Library Name: sg13cmos5l_stdcell
* Cell Name:    sg13cmos5l_fill_4
* View Name:    schematic
************************************************************************

.SUBCKT sg13cmos5l_fill_4 VDD VSS
*.PININFO VDD:B VSS:B
.ENDS

************************************************************************
* Library Name: sg13cmos5l_stdcell
* Cell Name:    sg13cmos5l_fill_8
* View Name:    schematic
************************************************************************

.SUBCKT sg13cmos5l_fill_8 VDD VSS
*.PININFO VDD:B VSS:B
.ENDS

* ===== end of the concatenated CDL
