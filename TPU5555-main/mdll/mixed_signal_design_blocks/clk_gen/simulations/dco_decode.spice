** Behavioural model of dco_decode (6-bit binary -> 63 thermometer, plus
** the dither: unit N for the last code[1:0] periods of a run, from the
** divider's Gray period count g[1:0]).
** Generated by simulations/gen_decode_spice.py -- do not edit by hand.
** Logic is SAT-proven against the RTL; gate delay is omitted deliberately.

.subckt dco_decode code[7] code[6] code[5] code[4] code[3] code[2] code[1] code[0] g[1] g[0] co0[7] co0[6] co0[5] co0[4] co0[3] co0[2] co0[1] co0[0] cob0[7] cob0[6] cob0[5] cob0[4] cob0[3] cob0[2] cob0[1] cob0[0] co1[7] co1[6] co1[5] co1[4] co1[3] co1[2] co1[1] co1[0] cob1[7] cob1[6] cob1[5] cob1[4] cob1[3] cob1[2] cob1[1] cob1[0] co2[7] co2[6] co2[5] co2[4] co2[3] co2[2] co2[1] co2[0] cob2[7] cob2[6] cob2[5] cob2[4] cob2[3] cob2[2] cob2[1] cob2[0] co3[7] co3[6] co3[5] co3[4] co3[3] co3[2] co3[1] co3[0] cob3[7] cob3[6] cob3[5] cob3[4] cob3[3] cob3[2] cob3[1] cob3[0] params: vhi=1.2 vth=0.6

* Decoded value of code[7:2] as a voltage on an internal node.
Bnsum nsum 0 V = (v(code[7]) > vth) * 32 + (v(code[6]) > vth) * 16 + (v(code[5]) > vth) * 8 + (v(code[4]) > vth) * 4 + (v(code[3]) > vth) * 2 + (v(code[2]) > vth) * 1

* frac_on: this period is one of the last k = code[1:0] of the run.
* g = 00 01 11 10 in periods 0..3: k=1 -> g1&~g0, k=2 -> g1, k=3 -> g1|g0.
Bk kk 0 V = (v(code[1]) > vth) * 2 + (v(code[0]) > vth)
Bg1 gg1 0 V = (v(g[1]) > vth)
Bg0 gg0 0 V = (v(g[0]) > vth)
Bfr fr 0 V = (abs(v(kk) - 1) < 0.5) * v(gg1) * (1 - v(gg0)) + (abs(v(kk) - 2) < 0.5) * v(gg1) + (abs(v(kk) - 3) < 0.5) * (1 - (1 - v(gg1)) * (1 - v(gg0)))

* Unit i is on below N, and unit N while frac_on: N + frac_on > i.
* One unit cap per thermometer bit; slot 63 has no bit and ties low.
Bco0_7 co0[7] 0 V = (v(nsum) + v(fr) > 56.5) ? vhi : 0
Bco0_6 co0[6] 0 V = (v(nsum) + v(fr) > 48.5) ? vhi : 0
Bco0_5 co0[5] 0 V = (v(nsum) + v(fr) > 40.5) ? vhi : 0
Bco0_4 co0[4] 0 V = (v(nsum) + v(fr) > 32.5) ? vhi : 0
Bco0_3 co0[3] 0 V = (v(nsum) + v(fr) > 24.5) ? vhi : 0
Bco0_2 co0[2] 0 V = (v(nsum) + v(fr) > 16.5) ? vhi : 0
Bco0_1 co0[1] 0 V = (v(nsum) + v(fr) > 8.5) ? vhi : 0
Bco0_0 co0[0] 0 V = (v(nsum) + v(fr) > 0.5) ? vhi : 0
Bcob0_7 cob0[7] 0 V = (v(nsum) + v(fr) > 57.5) ? vhi : 0
Bcob0_6 cob0[6] 0 V = (v(nsum) + v(fr) > 49.5) ? vhi : 0
Bcob0_5 cob0[5] 0 V = (v(nsum) + v(fr) > 41.5) ? vhi : 0
Bcob0_4 cob0[4] 0 V = (v(nsum) + v(fr) > 33.5) ? vhi : 0
Bcob0_3 cob0[3] 0 V = (v(nsum) + v(fr) > 25.5) ? vhi : 0
Bcob0_2 cob0[2] 0 V = (v(nsum) + v(fr) > 17.5) ? vhi : 0
Bcob0_1 cob0[1] 0 V = (v(nsum) + v(fr) > 9.5) ? vhi : 0
Bcob0_0 cob0[0] 0 V = (v(nsum) + v(fr) > 1.5) ? vhi : 0
Bco1_7 co1[7] 0 V = (v(nsum) + v(fr) > 58.5) ? vhi : 0
Bco1_6 co1[6] 0 V = (v(nsum) + v(fr) > 50.5) ? vhi : 0
Bco1_5 co1[5] 0 V = (v(nsum) + v(fr) > 42.5) ? vhi : 0
Bco1_4 co1[4] 0 V = (v(nsum) + v(fr) > 34.5) ? vhi : 0
Bco1_3 co1[3] 0 V = (v(nsum) + v(fr) > 26.5) ? vhi : 0
Bco1_2 co1[2] 0 V = (v(nsum) + v(fr) > 18.5) ? vhi : 0
Bco1_1 co1[1] 0 V = (v(nsum) + v(fr) > 10.5) ? vhi : 0
Bco1_0 co1[0] 0 V = (v(nsum) + v(fr) > 2.5) ? vhi : 0
Bcob1_7 cob1[7] 0 V = (v(nsum) + v(fr) > 59.5) ? vhi : 0
Bcob1_6 cob1[6] 0 V = (v(nsum) + v(fr) > 51.5) ? vhi : 0
Bcob1_5 cob1[5] 0 V = (v(nsum) + v(fr) > 43.5) ? vhi : 0
Bcob1_4 cob1[4] 0 V = (v(nsum) + v(fr) > 35.5) ? vhi : 0
Bcob1_3 cob1[3] 0 V = (v(nsum) + v(fr) > 27.5) ? vhi : 0
Bcob1_2 cob1[2] 0 V = (v(nsum) + v(fr) > 19.5) ? vhi : 0
Bcob1_1 cob1[1] 0 V = (v(nsum) + v(fr) > 11.5) ? vhi : 0
Bcob1_0 cob1[0] 0 V = (v(nsum) + v(fr) > 3.5) ? vhi : 0
Bco2_7 co2[7] 0 V = (v(nsum) + v(fr) > 60.5) ? vhi : 0
Bco2_6 co2[6] 0 V = (v(nsum) + v(fr) > 52.5) ? vhi : 0
Bco2_5 co2[5] 0 V = (v(nsum) + v(fr) > 44.5) ? vhi : 0
Bco2_4 co2[4] 0 V = (v(nsum) + v(fr) > 36.5) ? vhi : 0
Bco2_3 co2[3] 0 V = (v(nsum) + v(fr) > 28.5) ? vhi : 0
Bco2_2 co2[2] 0 V = (v(nsum) + v(fr) > 20.5) ? vhi : 0
Bco2_1 co2[1] 0 V = (v(nsum) + v(fr) > 12.5) ? vhi : 0
Bco2_0 co2[0] 0 V = (v(nsum) + v(fr) > 4.5) ? vhi : 0
Bcob2_7 cob2[7] 0 V = (v(nsum) + v(fr) > 61.5) ? vhi : 0
Bcob2_6 cob2[6] 0 V = (v(nsum) + v(fr) > 53.5) ? vhi : 0
Bcob2_5 cob2[5] 0 V = (v(nsum) + v(fr) > 45.5) ? vhi : 0
Bcob2_4 cob2[4] 0 V = (v(nsum) + v(fr) > 37.5) ? vhi : 0
Bcob2_3 cob2[3] 0 V = (v(nsum) + v(fr) > 29.5) ? vhi : 0
Bcob2_2 cob2[2] 0 V = (v(nsum) + v(fr) > 21.5) ? vhi : 0
Bcob2_1 cob2[1] 0 V = (v(nsum) + v(fr) > 13.5) ? vhi : 0
Bcob2_0 cob2[0] 0 V = (v(nsum) + v(fr) > 5.5) ? vhi : 0
Bco3_7 co3[7] 0 V = (v(nsum) + v(fr) > 62.5) ? vhi : 0
Bco3_6 co3[6] 0 V = (v(nsum) + v(fr) > 54.5) ? vhi : 0
Bco3_5 co3[5] 0 V = (v(nsum) + v(fr) > 46.5) ? vhi : 0
Bco3_4 co3[4] 0 V = (v(nsum) + v(fr) > 38.5) ? vhi : 0
Bco3_3 co3[3] 0 V = (v(nsum) + v(fr) > 30.5) ? vhi : 0
Bco3_2 co3[2] 0 V = (v(nsum) + v(fr) > 22.5) ? vhi : 0
Bco3_1 co3[1] 0 V = (v(nsum) + v(fr) > 14.5) ? vhi : 0
Bco3_0 co3[0] 0 V = (v(nsum) + v(fr) > 6.5) ? vhi : 0
Bcob3_7 cob3[7] 0 V = 0   $ slot 63: tied low
Bcob3_6 cob3[6] 0 V = (v(nsum) + v(fr) > 55.5) ? vhi : 0
Bcob3_5 cob3[5] 0 V = (v(nsum) + v(fr) > 47.5) ? vhi : 0
Bcob3_4 cob3[4] 0 V = (v(nsum) + v(fr) > 39.5) ? vhi : 0
Bcob3_3 cob3[3] 0 V = (v(nsum) + v(fr) > 31.5) ? vhi : 0
Bcob3_2 cob3[2] 0 V = (v(nsum) + v(fr) > 23.5) ? vhi : 0
Bcob3_1 cob3[1] 0 V = (v(nsum) + v(fr) > 15.5) ? vhi : 0
Bcob3_0 cob3[0] 0 V = (v(nsum) + v(fr) > 7.5) ? vhi : 0

.ends
