** DCO characterisation: oscillation frequency vs. 6-bit thermometer code.
**
** Generated by simulations/gen_char_dco.py -- do not edit by hand.
** The cap bank is 63 identical custom_cap_4 units; enabled-unit count equals
** the code exactly, so the period must rise monotonically with the code.

.LIB /opt/IHP-Open-PDK/ihp-sg13g2/libs.tech/ngspice/models/cornerMOSlv.lib mos_tt
.OPTIONS KLU
.INCLUDE /opt/IHP-Open-PDK/ihp-sg13g2/libs.ref/sg13g2_stdcell/spice/sg13g2_stdcell.spice
.INCLUDE /home/michael/Documents/Passionate/custom_stdcell/custom_stdcell.spice
.PARAM VDD=1.2
.TEMP 27

* ---- delay_cell, mirroring the xschem export of src/delay_cell.sch ----
.subckt delay_cell in out co[7] co[6] co[5] co[4] co[3] co[2] co[1] co[0] cob[7] cob[6] cob[5] cob[4] cob[3] cob[2] cob[1] cob[0] outb inb
x13 out in VDD VSS sg13g2_inv_1
x14 outb inb VDD VSS sg13g2_inv_1
x11 out outb VDD VSS sg13g2_inv_1
x12 outb out VDD VSS sg13g2_inv_1
xco0 co[0] out VDD VSS custom_cap_4
xco1 co[1] out VDD VSS custom_cap_4
xco2 co[2] out VDD VSS custom_cap_4
xco3 co[3] out VDD VSS custom_cap_4
xco4 co[4] out VDD VSS custom_cap_4
xco5 co[5] out VDD VSS custom_cap_4
xco6 co[6] out VDD VSS custom_cap_4
xco7 co[7] out VDD VSS custom_cap_4
xcob0 cob[0] outb VDD VSS custom_cap_4
xcob1 cob[1] outb VDD VSS custom_cap_4
xcob2 cob[2] outb VDD VSS custom_cap_4
xcob3 cob[3] outb VDD VSS custom_cap_4
xcob4 cob[4] outb VDD VSS custom_cap_4
xcob5 cob[5] outb VDD VSS custom_cap_4
xcob6 cob[6] outb VDD VSS custom_cap_4
xcob7 cob[7] outb VDD VSS custom_cap_4
.ends

* ---- ring: 4 delay cells + injection mux ----
x3 net8 net7 t56 t48 t40 t32 t24 t16 t8 t0 t57 t49 t41 t33 t25 t17 t9 t1 net6 net9 delay_cell
x4 net7 net5 t58 t50 t42 t34 t26 t18 t10 t2 t59 t51 t43 t35 t27 t19 t11 t3 net1 net6 delay_cell
x5 net5 net2 t60 t52 t44 t36 t28 t20 t12 t4 t61 t53 t45 t37 t29 t21 t13 t5 net4 net1 delay_cell
x6 net2 ring_p t62 t54 t46 t38 t30 t22 t14 t6 VSS t55 t47 t39 t31 t23 t15 t7 ring_n net4 delay_cell
x7 net8 M_outb VDD VSS sg13g2_inv_2
x8 net9 M_out VDD VSS sg13g2_inv_2
x9 M_outb ring_p clk_ref sel VDD VSS sg13g2_mux2_2
x1 M_out ring_n clk_refb sel VDD VSS sg13g2_mux2_2

xb1 tb1 ring_p VDD VSS sg13g2_inv_1
xb2 tb2 tb1 VDD VSS sg13g2_inv_4
x2 clk_outb tb2 VDD VSS sg13g2_inv_16
xb3 tb3 ring_n VDD VSS sg13g2_inv_1
xb4 tb4 tb3 VDD VSS sg13g2_inv_4
x10 clk_out tb4 VDD VSS sg13g2_inv_16

VVDD VDD 0 DC {VDD}
VVSS VSS 0 0
Vsel sel 0 0          $ free-running: mux selects the ring, not clk_ref
Vref clk_ref 0 0
Vrefb clk_refb 0 {VDD}

* One swept control voltage; each thermometer node derives from it, so
* the loop alters a single source instead of 63.
Vcode code 0 DC 0
Bt0 t0 0 V = (v(code) > 0.5) ? {VDD} : 0
Bt1 t1 0 V = (v(code) > 1.5) ? {VDD} : 0
Bt2 t2 0 V = (v(code) > 2.5) ? {VDD} : 0
Bt3 t3 0 V = (v(code) > 3.5) ? {VDD} : 0
Bt4 t4 0 V = (v(code) > 4.5) ? {VDD} : 0
Bt5 t5 0 V = (v(code) > 5.5) ? {VDD} : 0
Bt6 t6 0 V = (v(code) > 6.5) ? {VDD} : 0
Bt7 t7 0 V = (v(code) > 7.5) ? {VDD} : 0
Bt8 t8 0 V = (v(code) > 8.5) ? {VDD} : 0
Bt9 t9 0 V = (v(code) > 9.5) ? {VDD} : 0
Bt10 t10 0 V = (v(code) > 10.5) ? {VDD} : 0
Bt11 t11 0 V = (v(code) > 11.5) ? {VDD} : 0
Bt12 t12 0 V = (v(code) > 12.5) ? {VDD} : 0
Bt13 t13 0 V = (v(code) > 13.5) ? {VDD} : 0
Bt14 t14 0 V = (v(code) > 14.5) ? {VDD} : 0
Bt15 t15 0 V = (v(code) > 15.5) ? {VDD} : 0
Bt16 t16 0 V = (v(code) > 16.5) ? {VDD} : 0
Bt17 t17 0 V = (v(code) > 17.5) ? {VDD} : 0
Bt18 t18 0 V = (v(code) > 18.5) ? {VDD} : 0
Bt19 t19 0 V = (v(code) > 19.5) ? {VDD} : 0
Bt20 t20 0 V = (v(code) > 20.5) ? {VDD} : 0
Bt21 t21 0 V = (v(code) > 21.5) ? {VDD} : 0
Bt22 t22 0 V = (v(code) > 22.5) ? {VDD} : 0
Bt23 t23 0 V = (v(code) > 23.5) ? {VDD} : 0
Bt24 t24 0 V = (v(code) > 24.5) ? {VDD} : 0
Bt25 t25 0 V = (v(code) > 25.5) ? {VDD} : 0
Bt26 t26 0 V = (v(code) > 26.5) ? {VDD} : 0
Bt27 t27 0 V = (v(code) > 27.5) ? {VDD} : 0
Bt28 t28 0 V = (v(code) > 28.5) ? {VDD} : 0
Bt29 t29 0 V = (v(code) > 29.5) ? {VDD} : 0
Bt30 t30 0 V = (v(code) > 30.5) ? {VDD} : 0
Bt31 t31 0 V = (v(code) > 31.5) ? {VDD} : 0
Bt32 t32 0 V = (v(code) > 32.5) ? {VDD} : 0
Bt33 t33 0 V = (v(code) > 33.5) ? {VDD} : 0
Bt34 t34 0 V = (v(code) > 34.5) ? {VDD} : 0
Bt35 t35 0 V = (v(code) > 35.5) ? {VDD} : 0
Bt36 t36 0 V = (v(code) > 36.5) ? {VDD} : 0
Bt37 t37 0 V = (v(code) > 37.5) ? {VDD} : 0
Bt38 t38 0 V = (v(code) > 38.5) ? {VDD} : 0
Bt39 t39 0 V = (v(code) > 39.5) ? {VDD} : 0
Bt40 t40 0 V = (v(code) > 40.5) ? {VDD} : 0
Bt41 t41 0 V = (v(code) > 41.5) ? {VDD} : 0
Bt42 t42 0 V = (v(code) > 42.5) ? {VDD} : 0
Bt43 t43 0 V = (v(code) > 43.5) ? {VDD} : 0
Bt44 t44 0 V = (v(code) > 44.5) ? {VDD} : 0
Bt45 t45 0 V = (v(code) > 45.5) ? {VDD} : 0
Bt46 t46 0 V = (v(code) > 46.5) ? {VDD} : 0
Bt47 t47 0 V = (v(code) > 47.5) ? {VDD} : 0
Bt48 t48 0 V = (v(code) > 48.5) ? {VDD} : 0
Bt49 t49 0 V = (v(code) > 49.5) ? {VDD} : 0
Bt50 t50 0 V = (v(code) > 50.5) ? {VDD} : 0
Bt51 t51 0 V = (v(code) > 51.5) ? {VDD} : 0
Bt52 t52 0 V = (v(code) > 52.5) ? {VDD} : 0
Bt53 t53 0 V = (v(code) > 53.5) ? {VDD} : 0
Bt54 t54 0 V = (v(code) > 54.5) ? {VDD} : 0
Bt55 t55 0 V = (v(code) > 55.5) ? {VDD} : 0
Bt56 t56 0 V = (v(code) > 56.5) ? {VDD} : 0
Bt57 t57 0 V = (v(code) > 57.5) ? {VDD} : 0
Bt58 t58 0 V = (v(code) > 58.5) ? {VDD} : 0
Bt59 t59 0 V = (v(code) > 59.5) ? {VDD} : 0
Bt60 t60 0 V = (v(code) > 60.5) ? {VDD} : 0
Bt61 t61 0 V = (v(code) > 61.5) ? {VDD} : 0
Bt62 t62 0 V = (v(code) > 62.5) ? {VDD} : 0

.ic v(M_out)=0 v(M_outb)=1.2
.save v(M_out)

.control
set noaskquit
set filetype=ascii
echo code freq > dco_char.csv
let code = 0
while code <= 63
  alter Vcode = code
  tran 20p 220n uic
  meas tran ta when v(M_out)=0.6 rise=5 td=25n
  meas tran tb when v(M_out)=0.6 rise=15 td=25n
  if length(ta) > 0
    let fr = 10/(tb-ta)
    echo "$&code $&fr" >> dco_char.csv
  else
    echo "$&code FAIL" >> dco_char.csv
  end
  destroy all
  let code = code + 1
end
quit
.endc

.GLOBAL VSS
.GLOBAL VDD
.end
